|   IBIS file stm32l431_433_443_lqfp64.ibs
[IBIS ver]   4.2
[File name]   stm32l431_433_443_lqfp64.ibs
[File Rev]   4.0
[Date]   08-10-2018
[Source]   Data Created at STMicroelectronics
[Notes]   File originated from ELDO simulations.
[Disclaimer]  This information is for modeling purpose only and is
   not guaranteed.
   The information is subject to change without notice.
[Copyright]   Copyright 2018 STMicroelectronics Inc.
|   Component stm32l431_433_443_lqfp64
[Component] stm32l431_433_443_lqfp64
[Manufacturer] STMicroelectronics
[Package]
| variable   typ   min   max
R_pkg   0.0   0.0   0.0
L_pkg   0.0H   0.0H   0.0H
C_pkg   0.0F   0.0F   0.0F
[Pin]  signal_name   model_name   R_pin   L_pin   C_pin
1 VBAT POWER 68.980E-3 4.220E-9 120.000E-15
2 PC13 io8prog2m25m50m120m_sudq_ft 63.756E-3 3.679E-9 93.469E-15
3 PC14-OSC32_IN io8prog2m25m50m120m_sudq_ft 59.336E-3 3.221E-9 71.020E-15
4 PC15-OSC32_OUT io8prog2m25m50m120m_sudq_ft 55.719E-3 2.846E-9 52.653E-15
5 PH0-OSC_IN io8prog2m25m50m120m_sudq_ft 52.907E-3 2.555E-9 38.367E-15
6 PH1-OSC_OUT io8prog2m25m50m120m_sudq_ft 50.897E-3 2.347E-9 28.163E-15
7 NRST ioreset_ft_v33 49.692E-3 2.222E-9 22.041E-15
8 PC0 io8prog2m25m50m120m_sudq_i2c_ft 49.290E-3 2.180E-9 20.000E-15
9 PC1 io8prog2m25m50m120m_sudq_i2c_ft 49.290E-3 2.180E-9 20.000E-15
10 PC2 io8prog2m25m50m120m_sudq_ft 49.692E-3 2.222E-9 22.041E-15
11 PC3 io8prog2m25m50m120m_sudq_ft 50.897E-3 2.347E-9 28.163E-15
12 VSSA/VREF- GND 52.907E-3 2.555E-9 38.367E-15
13 VDDA/VREF+ POWER 55.719E-3 2.846E-9 52.653E-15
14 PA0 io8prog2m25m50m120m_sudq_ft 59.336E-3 3.221E-9 71.020E-15
15 PA1 io8prog2m25m50m120m_sudq_ft 63.756E-3 3.679E-9 93.469E-15
16 PA2 io8prog2m25m50m120m_sudq_ft 68.980E-3 4.220E-9 120.000E-15
17 PA3 io8prog2m25m50m120m_sudq_ft 68.980E-3 4.220E-9 120.000E-15
18 VSS GND 63.756E-3 3.679E-9 93.469E-15
19 VDD POWER 59.336E-3 3.221E-9 71.020E-15
20 PA4 io8prog2m25m50m120m_sudq_ft 55.719E-3 2.846E-9 52.653E-15
21 PA5 io8prog2m25m50m120m_sudq_ft 52.907E-3 2.555E-9 38.367E-15
22 PA6 io8prog2m25m50m120m_sudq_ft 50.897E-3 2.347E-9 28.163E-15
23 PA7 io8prog2m25m50m120m_sudq_i2c_ft 49.692E-3 2.222E-9 22.041E-15
24 PC4 io8prog2m25m50m120m_sudq_ft 49.290E-3 2.180E-9 20.000E-15
25 PC5 io8prog2m25m50m120m_sudq_ft 49.290E-3 2.180E-9 20.000E-15
26 PB0 io8prog2m25m50m120m_sudq_ft 49.692E-3 2.222E-9 22.041E-15
27 PB1 io8prog2m25m50m120m_sudq_ft 50.897E-3 2.347E-9 28.163E-15
28 PB2 io8prog2m25m50m120m_sudq_ft 52.907E-3 2.555E-9 38.367E-15
29 PB10 io8prog2m25m50m120m_sudq_i2c_ft 55.719E-3 2.846E-9 52.653E-15
30 PB11 io8prog2m25m50m120m_sudq_i2c_ft 59.336E-3 3.221E-9 71.020E-15
31 VSS GND 63.756E-3 3.679E-9 93.469E-15
32 VDD POWER 68.980E-3 4.220E-9 120.000E-15
33 PB12 io8w_swp_lcd4_ft 68.980E-3 4.220E-9 120.000E-15
34 PB13 io8prog2m25m50m120m_sudq_i2c_ft 63.756E-3 3.679E-9 93.469E-15
35 PB14 io8prog2m25m50m120m_sudq_i2c_ft 59.336E-3 3.221E-9 71.020E-15
36 PB15 io8prog2m25m50m120m_sudq_ft 55.719E-3 2.846E-9 52.653E-15
37 PC6 io8prog2m25m50m120m_sudq_ft 52.907E-3 2.555E-9 38.367E-15
38 PC7 io8prog2m25m50m120m_sudq_ft 50.897E-3 2.347E-9 28.163E-15
39 PC8 io8prog2m25m50m120m_sudq_ft 49.692E-3 2.222E-9 22.041E-15
40 PC9 io8prog2m25m50m120m_sudq_ft 49.290E-3 2.180E-9 20.000E-15
41 PA8 io8w_swp_lcd4_ft 49.290E-3 2.180E-9 20.000E-15
42 PA9 io8prog2m25m50m120m_sudq_i2c_ft 49.692E-3 2.222E-9 22.041E-15
43 PA10 io8prog2m25m50m120m_sudq_i2c_ft 50.897E-3 2.347E-9 28.163E-15
44 PA11 io8usblsfs_otg2 52.907E-3 2.555E-9 38.367E-15
45 PA12 io8usblsfs_otg2 55.719E-3 2.846E-9 52.653E-15
46 PA13 io8prog2m25m50m120m_sudq_ft 59.336E-3 3.221E-9 71.020E-15
47 VSS GND 63.756E-3 3.679E-9 93.469E-15
48 VDDUSB/VDD POWER 68.980E-3 4.220E-9 120.000E-15
49 PA14 io8prog2m25m50m120m_sudq_ft 68.980E-3 4.220E-9 120.000E-15
50 PA15 io8prog2m25m50m120m_sudq_ft 63.756E-3 3.679E-9 93.469E-15
51 PC10 io8prog2m25m50m120m_sudq_ft 59.336E-3 3.221E-9 71.020E-15
52 PC11 io8prog2m25m50m120m_sudq_ft 55.719E-3 2.846E-9 52.653E-15
53 PC12 io8prog2m25m50m120m_sudq_ft 52.907E-3 2.555E-9 38.367E-15
54 PD2 io8prog2m25m50m120m_sudq_ft 50.897E-3 2.347E-9 28.163E-15
55 PB3 io8prog2m25m50m120m_sudq_ft 49.692E-3 2.222E-9 22.041E-15
56 PB4 io8prog2m25m50m120m_sudq_i2c_ft 49.290E-3 2.180E-9 20.000E-15
57 PB5 io8prog2m25m50m120m_sudq_ft 49.290E-3 2.180E-9 20.000E-15
58 PB6 io8prog2m25m50m120m_sudq_i2c_ft 49.692E-3 2.222E-9 22.041E-15
59 PB7 io8prog2m25m50m120m_sudq_i2c_ft 50.897E-3 2.347E-9 28.163E-15
60 PH3/BOOT0 io8prog2m25m50m120m_sudq_ft 52.907E-3 2.555E-9 38.367E-15
61 PB8 io8prog2m25m50m120m_sudq_i2c_ft 55.719E-3 2.846E-9 52.653E-15
62 PB9 io8prog2m25m50m120m_sudq_i2c_ft 59.336E-3 3.221E-9 71.020E-15
63 VSS GND 63.756E-3 3.679E-9 93.469E-15
64 VDD POWER 68.980E-3 4.220E-9 120.000E-15
[Diff Pin]   inv_pin   vdiff   tdelay_typ  tdelay_min  tdelay_max
44 45 200mV   NA   NA   NA
[Model Selector] io8usblsfs_otg2
usb_ls_pd  "USB Low Speed mode - Pull Down"
usb_ls_pu2  "USB Low Speed mode - Pull up 2"
usb_ls_pu  "USB Low Speed mode - Pull up"
usb_fs  "USB Low Speed mode"
usb_fs_pd  "USB Full Speed mode - Pull Down"
usb_fs_pu2  "USB Full Speed mode - Pull up 2"
usb_fs_pu  "USB Full Speed mode - Pull up"
[Model Selector] io8w_swp_lcd4_ft
io8w_swp_classc  "Class C swp functionality"
io8w_swp_classb  "Class B swp functionality"
io8lsw_1v8_pd  "GPIO 1.8V range with pd io low speed"
io8lsw_1v8_pu  "GPIO 1.8V range with pu io low speed"
io8lsw_1v8  "GPIO 1.8V range io low speed"
io8lsw_3v3_pd  "GPIO 3.3V range with pd io low speed"
io8lsw_3v3_pu  "GPIO 3.3V range with pu io low speed"
io8lsw_3v3  "GPIO 3.3V range io low speed"
io8fsw_1v8_pd  "GPIO 1.8V range with pd io full speed"
io8fsw_1v8_pu  "GPIO 1.8V range with pu io full speed"
io8fsw_1v8  "GPIO 1.8V range io full speed"
io8fsw_3v3_pd  "GPIO 3.3V range with pd io full speed"
io8fsw_3v3_pu  "GPIO 3.3V range with pu io full speed"
io8fsw_3v3  "GPIO 3.3V range io full speed"
io8msw_1v8_pd  "GPIO 1.8V range with pd io medium speed"
io8msw_1v8_pu  "GPIO 1.8V range with pu io medium speed"
io8msw_1v8  "GPIO 1.8V range io medium speed"
io8msw_3v3_pd  "GPIO 3.3V range with pd io medium speed"
io8msw_3v3_pu  "GPIO 3.3V range with pu io medium speed"
io8msw_3v3  "GPIO 3.3V range io medium speed"
io8hsw_1v8_pd  "GPIO 1.8V range with pd io high speed"
io8hsw_1v8_pu  "GPIO 1.8V range with pu io high speed"
io8hsw_1v8  "GPIO 1.8V range io high speed"
io8hsw_3v3_pd  "GPIO 3.3V range with pd io high speed"
io8hsw_3v3_pu  "GPIO 3.3V range with pu io high speed"
io8hsw_3v3  "GPIO 3.3V range io high speed"
[Model Selector] io8prog2m25m50m120m_sudq_ft
iols8p_sudq_ft_pd_lv  "IO low speed, PD=40kOhm - 1P8V"
iols8p_sudq_ft_pu_lv  "IO low speed, PU=40kOhm - 1P8V"
iols8p_sudq_ft_lv  "IO low speed - 1P8V"
iols8p_sudq_ft_pd  "IO low speed, PD=40kOhm - 3P3V"
iols8p_sudq_ft_pu  "IO low speed, PU=40kOhm - 3P3V"
iols8p_sudq_ft  "IO low speed - 3P3V"
iofs8p_sudq_ft_pd_lv  "IO full speed, PD=40kOhm - 1P8V"
iofs8p_sudq_ft_pu_lv  "IO full speed, PU=40kOhm - 1P8V"
iofs8p_sudq_ft_lv  "IO full speed - 1P8V"
iofs8p_sudq_ft_pd  "IO full speed, PD=40kOhm - 3P3V"
iofs8p_sudq_ft_pu  "IO full speed, PU=40kOhm - 3P3V"
iofs8p_sudq_ft  "IO full speed - 3P3V"
ioms8p_sudq_ft_pd_lv  "IO medium speed, PD=40kOhm - 1P8V"
ioms8p_sudq_ft_pu_lv  "IO medium speed, PU=40kOhm - 1P8V"
ioms8p_sudq_ft_lv  "IO medium speed - 1P8V"
ioms8p_sudq_ft_pd  "IO medium speed, PD=40kOhm - 3P3V"
ioms8p_sudq_ft_pu  "IO medium speed, PU=40kOhm - 3P3V"
ioms8p_sudq_ft  "IO medium speed - 3P3V"
iohs8p_sudq_ft_pd_lv  "IO high speed, PD=40kOhm - 1P8V"
iohs8p_sudq_ft_pu_lv  "IO high speed, PU=40kOhm - 1P8V"
iohs8p_sudq_ft_lv  "IO high speed - 1P8V"
iohs8p_sudq_ft_pd  "IO high speed, PD=40kOhm - 3P3V"
iohs8p_sudq_ft_pu  "IO high speed, PU=40kOhm - 3P3V"
iohs8p_sudq_ft  "IO high speed - 3P3V"
[Model Selector] io8prog2m25m50m120m_sudq_i2c_ft
io8prog_1v8_i2c_pd  "5V Tol GPIO 1.8V range i2c functionality with pull down"
io8prog_1v8_i2c_pu  "5V Tol GPIO 1.8V range i2c functionality with pull up"
io8prog_1v8_i2c  "5V Tol GPIO 1.8V range i2c functionality"
io8prog_3v3_i2c_pd  "5V Tol GPIO 3.3V range i2c functionality with pull down"
io8prog_3v3_i2c_pu  "5V Tol GPIO 3.3V range i2c functionality with pull up"
io8prog_3v3_i2c  "5V Tol GPIO 3.3V range i2c functionality"
io8ls_1v8_pd  "5V Tol GPIO 1.8V range with pd io low speed"
io8ls_1v8_pu  "5V Tol GPIO 1.8V range with pu io low speed"
io8ls_1v8  "5V Tol GPIO 1.8V range io low speed"
io8ls_3v3_pd  "5V Tol GPIO 3.3V range with pd io low speed"
io8ls_3v3_pu  "5V Tol GPIO 3.3V range with pu io low speed"
io8ls_3v3  "5V Tol GPIO 3.3V range io low speed"
io8fs_1v8_pd  "5V Tol GPIO 1.8V range with pd io full speed"
io8fs_1v8_pu  "5V Tol GPIO 1.8V range with pu io full speed"
io8fs_1v8  "5V Tol GPIO 1.8V range io full speed"
io8fs_3v3_pd  "5V Tol GPIO 3.3V range with pd io full speed"
io8fs_3v3_pu  "5V Tol GPIO 3.3V range with pu io full speed"
io8fs_3v3  "5V Tol GPIO 3.3V range io full speed"
io8ms_1v8_pd  "5V Tol GPIO 1.8V range with pd io medium speed"
io8ms_1v8_pu  "5V Tol GPIO 1.8V range with pu io medium speed"
io8ms_1v8  "5V Tol GPIO 1.8V range io medium speed"
io8ms_3v3_pd  "5V Tol GPIO 3.3V range with pd io medium speed"
io8ms_3v3_pu  "5V Tol GPIO 3.3V range with pu io medium speed"
io8ms_3v3  "5V Tol GPIO 3.3V range io medium speed"
io8hs_1v8_pd  "5V Tol GPIO 1.8V range with pd io high speed"
io8hs_1v8_pu  "5V Tol GPIO 1.8V range with pu io high speed"
io8hs_1v8  "5V Tol GPIO 1.8V range io high speed"
io8hs_3v3_pd  "5V Tol GPIO 3.3V range with pd io high speed"
io8hs_3v3_pu  "5V Tol GPIO 3.3V range with pu io high speed"
io8hs_3v3  "5V Tol GPIO 3.3V range io high speed"
[Model Selector] ioreset_ft_v33
ioreset_1v2_pu  "RESET 1.2V range with PU"
ioreset_1v2  "RESET 1.2V range"
ioreset_1v8_pu  "RESET 1.8V range with PU"
ioreset_1v8  "RESET 1.8V range"
ioreset_3v3_pu  "RESET 3.3V range with PU"
ioreset_3v3  "RESET 3.3V range"
| Models and submodels in the file (93): usb_ls_pd (I/O), usb_ls_pu2 (I/O), usb_ls_pu (I/O), usb_fs (I/O), usb_fs_pd (I/O), usb_fs_pu2 (I/O), usb_fs_pu (I/O), io8w_swp_classc (I/O), io8w_swp_classb (I/O), io8lsw_1v8_pd (I/O), io8lsw_1v8_pu (I/O), io8lsw_1v8 (I/O), io8lsw_3v3_pd (I/O), io8lsw_3v3_pu (I/O), io8lsw_3v3 (I/O), io8fsw_1v8_pd (I/O), io8fsw_1v8_pu (I/O), io8fsw_1v8 (I/O), io8fsw_3v3_pd (I/O), io8fsw_3v3_pu (I/O), io8fsw_3v3 (I/O), io8msw_1v8_pd (I/O), io8msw_1v8_pu (I/O), io8msw_1v8 (I/O), io8msw_3v3_pd (I/O), io8msw_3v3_pu (I/O), io8msw_3v3 (I/O), io8hsw_1v8_pd (I/O), io8hsw_1v8_pu (I/O), io8hsw_1v8 (I/O), io8hsw_3v3_pd (I/O), io8hsw_3v3_pu (I/O), io8hsw_3v3 (I/O), iols8p_sudq_ft_pd_lv (I/O), iols8p_sudq_ft_pu_lv (I/O), iols8p_sudq_ft_lv (I/O), iols8p_sudq_ft_pd (I/O), iols8p_sudq_ft_pu (I/O), iols8p_sudq_ft (I/O), iofs8p_sudq_ft_pd_lv (I/O), iofs8p_sudq_ft_pu_lv (I/O), iofs8p_sudq_ft_lv (I/O), iofs8p_sudq_ft_pd (I/O), iofs8p_sudq_ft_pu (I/O), iofs8p_sudq_ft (I/O), ioms8p_sudq_ft_pd_lv (I/O), ioms8p_sudq_ft_pu_lv (I/O), ioms8p_sudq_ft_lv (I/O), ioms8p_sudq_ft_pd (I/O), ioms8p_sudq_ft_pu (I/O), ioms8p_sudq_ft (I/O), iohs8p_sudq_ft_pd_lv (I/O), iohs8p_sudq_ft_pu_lv (I/O), iohs8p_sudq_ft_lv (I/O), iohs8p_sudq_ft_pd (I/O), iohs8p_sudq_ft_pu (I/O), iohs8p_sudq_ft (I/O), io8prog_1v8_i2c_pd (I/O), io8prog_1v8_i2c_pu (I/O), io8prog_1v8_i2c (I/O), io8prog_3v3_i2c_pd (I/O), io8prog_3v3_i2c_pu (I/O), io8prog_3v3_i2c (I/O), io8ls_1v8_pd (I/O), io8ls_1v8_pu (I/O), io8ls_1v8 (I/O), io8ls_3v3_pd (I/O), io8ls_3v3_pu (I/O), io8ls_3v3 (I/O), io8fs_1v8_pd (I/O), io8fs_1v8_pu (I/O), io8fs_1v8 (I/O), io8fs_3v3_pd (I/O), io8fs_3v3_pu (I/O), io8fs_3v3 (I/O), io8ms_1v8_pd (I/O), io8ms_1v8_pu (I/O), io8ms_1v8 (I/O), io8ms_3v3_pd (I/O), io8ms_3v3_pu (I/O)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
