|   IBIS file stm32l412_422_lqfp48.ibs
[IBIS ver]   4.2
[File name]   stm32l412_422_lqfp48.ibs
[File Rev]   1.0
[Date]   08-10-2018
[Source]   Data Created at STMicroelectronics
[Notes]   File originated from ELDO simulations.
[Disclaimer]  This information is for modeling purpose only and is
   not guaranteed.
   The information is subject to change without notice.
[Copyright]   Copyright 2018 STMicroelectronics Inc.
|   Component stm32l412_422_lqfp48
[Component] stm32l412_422_lqfp48
[Manufacturer] STMicroelectronics
[Package]
| variable   typ   min   max
R_pkg   0   0   0
L_pkg   0   0   0
C_pkg   0   0   0
[Pin]   signal_name   model_name   R_pin   L_pin   C_pin
1 VBAT POWER 0.053 3.42534E-09 90.4E-15
2 PC13 io8prog2m25m50m120m_sudq_ft 48.4E-3 2.9E-9 64.4E-15
3 PC14-OSC32_IN io8prog2m25m50m120m_sudq_ft 44.7E-3 2.5E-9 43.7E-15
4 PC15-OSC32_OUT io8prog2m25m50m120m_sudq_ft 41.9E-3 2.2E-9 28.1E-15
5 PH0-OSC_IN io8prog2m25m50m120m_sudq_ft 40.1E-3 2.0E-9 17.7E-15
6 PH1-OSC_OUT io8prog2m25m50m120m_sudq_ft 0.03913 1.89021E-09 12.5E-15
7 NRST ioreset_ft_v33 0.03913 1.89021E-09 12.5E-15
8 VSSA/VREF- GND 40.1E-3 2.0E-9 17.8E-15
9 VDDA/VREF+ POWER 41.9E-3 2.2E-9 28.2E-15
10 PA0 io8prog2m25m50m120m_sudq_ft 44.7E-3 2.5E-9 43.8E-15
11 PA1 io8prog2m25m50m120m_sudq_ft 48.4E-3 2.9E-9 64.6E-15
12 PA2 io8prog2m25m50m120m_sudq_ft 0.053 3.42534E-09 90.4E-15
13 PA3 io8prog2m25m50m120m_sudq_ft 0.053 3.4E-9 90.4E-15
14 PA4 io8prog2m25m50m120m_sudq_ft 48.4E-3 2.9E-9 64.4E-15
15 PA5 io8prog2m25m50m120m_sudq_ft 44.7E-3 2.5E-9 43.7E-15
16 PA6 io8prog2m25m50m120m_sudq_ft 41.9E-3 2.2E-9 28.1E-15
17 PA7 io8prog2m25m50m120m_sudq_i2c_ft 40.1E-3 2.0E-9 17.7E-15
18 PB0 io8prog2m25m50m120m_sudq_ft 0.03913 1.9E-9 12.5E-15
19 PB1 io8prog2m25m50m120m_sudq_ft 0.03913 1.9E-9 12.5E-15
20 PB2 io8prog2m25m50m120m_sudq_ft 40.1E-3 2.0E-9 17.8E-15
21 PB10 io8prog2m25m50m120m_sudq_i2c_ft 41.9E-3 2.2E-9 28.2E-15
22 PB11 io8prog2m25m50m120m_sudq_i2c_ft 44.7E-3 2.5E-9 43.8E-15
23 VSS GND 48.4E-3 2.9E-9 64.6E-15
24 VDD POWER 0.053 3.4E-9 90.4E-15
25 PB12 io8prog2m25m50m120m_sudq_ft 0.053 3.4E-9 90.4E-15
26 PB13 io8prog2m25m50m120m_sudq_i2c_ft 48.4E-3 2.9E-9 64.4E-15
27 PB14 io8prog2m25m50m120m_sudq_i2c_ft 44.7E-3 2.5E-9 43.7E-15
28 PB15 io8prog2m25m50m120m_sudq_ft 41.9E-3 2.2E-9 28.1E-15
29 PA8 io8prog2m25m50m120m_sudq_ft 40.1E-3 2.0E-9 17.7E-15
30 PA9 io8prog2m25m50m120m_sudq_i2c_ft 0.03913 1.9E-9 12.5E-15
31 PA10 io8prog2m25m50m120m_sudq_i2c_ft 0.03913 1.9E-9 12.5E-15
32 PA11 io8usblsfs_otg2 40.1E-3 2.0E-9 17.8E-15
33 PA12 io8usblsfs_otg2 41.9E-3 2.2E-9 28.2E-15
34 PA13 io8prog2m25m50m120m_sudq_ft 44.7E-3 2.5E-9 43.8E-15
35 VSS GND 48.4E-3 2.9E-9 64.6E-15
36 VDDUSB POWER 0.053 3.4E-9 90.4E-15
37 PA14 io8prog2m25m50m120m_sudq_ft 0.053 3.4E-9 90.4E-15
38 PA15 io8prog2m25m50m120m_sudq_ft 48.4E-3 2.9E-9 64.4E-15
39 PB3 io8prog2m25m50m120m_sudq_ft 44.7E-3 2.5E-9 43.7E-15
40 PB4 io8prog2m25m50m120m_sudq_i2c_ft 41.9E-3 2.2E-9 28.1E-15
41 PB5 io8prog2m25m50m120m_sudq_ft 40.1E-3 2.0E-9 17.7E-15
42 PB6 io8prog2m25m50m120m_sudq_i2c_ft 0.03913 1.9E-9 12.5E-15
43 PB7 io8prog2m25m50m120m_sudq_i2c_ft 0.03913 1.9E-9 12.5E-15
44 PH3-BOOT0 io8prog2m25m50m120m_sudq_ft 40.1E-3 2.0E-9 17.8E-15
45 PB8 io8prog2m25m50m120m_sudq_i2c_ft 41.9E-3 2.2E-9 28.2E-15
46 PB9 io8prog2m25m50m120m_sudq_i2c_ft 44.7E-3 2.5E-9 43.8E-15
47 VSS GND 48.4E-3 2.9E-9 64.6E-15
48 VDD POWER 0.053 3.4E-9 90.4E-15
[Model Selector] io8prog2m25m50m120m_sudq_ft
iols8p_sudq_ft_pd_lv  "IO low speed, PD=40kOhm - 1P8V"
iols8p_sudq_ft_pu_lv  "IO low speed, PU=40kOhm - 1P8V"
iols8p_sudq_ft_lv  "IO low speed - 1P8V"
iols8p_sudq_ft_pd  "IO low speed, PD=40kOhm - 3P3V"
iols8p_sudq_ft_pu  "IO low speed, PU=40kOhm - 3P3V"
iols8p_sudq_ft  "IO low speed - 3P3V"
iofs8p_sudq_ft_pd_lv  "IO full speed, PD=40kOhm - 1P8V"
iofs8p_sudq_ft_pu_lv  "IO full speed, PU=40kOhm - 1P8V"
iofs8p_sudq_ft_lv  "IO full speed - 1P8V"
iofs8p_sudq_ft_pd  "IO full speed, PD=40kOhm - 3P3V"
iofs8p_sudq_ft_pu  "IO full speed, PU=40kOhm - 3P3V"
iofs8p_sudq_ft  "IO full speed - 3P3V"
ioms8p_sudq_ft_pd_lv  "IO medium speed, PD=40kOhm - 1P8V"
ioms8p_sudq_ft_pu_lv  "IO medium speed, PU=40kOhm - 1P8V"
ioms8p_sudq_ft_lv  "IO medium speed - 1P8V"
ioms8p_sudq_ft_pd  "IO medium speed, PD=40kOhm - 3P3V"
ioms8p_sudq_ft_pu  "IO medium speed, PU=40kOhm - 3P3V"
ioms8p_sudq_ft  "IO medium speed - 3P3V"
iohs8p_sudq_ft_pd_lv  "IO high speed, PD=40kOhm - 1P8V"
iohs8p_sudq_ft_pu_lv  "IO high speed, PU=40kOhm - 1P8V"
iohs8p_sudq_ft_lv  "IO high speed - 1P8V"
iohs8p_sudq_ft_pd  "IO high speed, PD=40kOhm - 3P3V"
iohs8p_sudq_ft_pu  "IO high speed, PU=40kOhm - 3P3V"
iohs8p_sudq_ft  "IO high speed - 3P3V"
[Model Selector] io8prog2m25m50m120m_sudq_i2c_ft
io8prog_1v8_i2c_pd  "5V Tol GPIO 1.8V range i2c functionality with pull down"
io8prog_1v8_i2c_pu  "5V Tol GPIO 1.8V range i2c functionality with pull up"
io8prog_1v8_i2c  "5V Tol GPIO 1.8V range i2c functionality"
io8prog_3v3_i2c_pd  "5V Tol GPIO 3.3V range i2c functionality with pull down"
io8prog_3v3_i2c_pu  "5V Tol GPIO 3.3V range i2c functionality with pull up"
io8prog_3v3_i2c  "5V Tol GPIO 3.3V range i2c functionality"
io8ls_1v8_pd  "5V Tol GPIO 1.8V range with pd io low speed"
io8ls_1v8_pu  "5V Tol GPIO 1.8V range with pu io low speed"
io8ls_1v8  "5V Tol GPIO 1.8V range io low speed"
io8ls_3v3_pd  "5V Tol GPIO 3.3V range with pd io low speed"
io8ls_3v3_pu  "5V Tol GPIO 3.3V range with pu io low speed"
io8ls_3v3  "5V Tol GPIO 3.3V range io low speed"
io8fs_1v8_pd  "5V Tol GPIO 1.8V range with pd io full speed"
io8fs_1v8_pu  "5V Tol GPIO 1.8V range with pu io full speed"
io8fs_1v8  "5V Tol GPIO 1.8V range io full speed"
io8fs_3v3_pd  "5V Tol GPIO 3.3V range with pd io full speed"
io8fs_3v3_pu  "5V Tol GPIO 3.3V range with pu io full speed"
io8fs_3v3  "5V Tol GPIO 3.3V range io full speed"
io8ms_1v8_pd  "5V Tol GPIO 1.8V range with pd io medium speed"
io8ms_1v8_pu  "5V Tol GPIO 1.8V range with pu io medium speed"
io8ms_1v8  "5V Tol GPIO 1.8V range io medium speed"
io8ms_3v3_pd  "5V Tol GPIO 3.3V range with pd io medium speed"
io8ms_3v3_pu  "5V Tol GPIO 3.3V range with pu io medium speed"
io8ms_3v3  "5V Tol GPIO 3.3V range io medium speed"
io8hs_1v8_pd  "5V Tol GPIO 1.8V range with pd io high speed"
io8hs_1v8_pu  "5V Tol GPIO 1.8V range with pu io high speed"
io8hs_1v8  "5V Tol GPIO 1.8V range io high speed"
io8hs_3v3_pd  "5V Tol GPIO 3.3V range with pd io high speed"
io8hs_3v3_pu  "5V Tol GPIO 3.3V range with pu io high speed"
io8hs_3v3  "5V Tol GPIO 3.3V range io high speed"
[Model Selector] io8usblsfs_otg2
usb_ls_pd  "USB Low Speed mode - Pull Down"
usb_ls_pu2  "USB Low Speed mode - Pull up 2"
usb_ls_pu  "USB Low Speed mode - Pull up"
usb_fs  "USB Low Speed mode"
usb_fs_pd  "USB Full Speed mode - Pull Down"
usb_fs_pu2  "USB Full Speed mode - Pull up 2"
usb_fs_pu  "USB Full Speed mode - Pull up"
[Model Selector] ioreset_ft_v33
ioreset_1v2_pu  "RESET 1.2V range with PU"
ioreset_1v2  "RESET 1.2V range"
ioreset_1v8_pu  "RESET 1.8V range with PU"
ioreset_1v8  "RESET 1.8V range"
ioreset_3v3_pu  "RESET 3.3V range with PU"
ioreset_3v3  "RESET 3.3V range"
| Models and submodels in the file (67): iols8p_sudq_ft_pd_lv (I/O), iols8p_sudq_ft_pu_lv (I/O), iols8p_sudq_ft_lv (I/O), iols8p_sudq_ft_pd (I/O), iols8p_sudq_ft_pu (I/O), iols8p_sudq_ft (I/O), iofs8p_sudq_ft_pd_lv (I/O), iofs8p_sudq_ft_pu_lv (I/O), iofs8p_sudq_ft_lv (I/O), iofs8p_sudq_ft_pd (I/O), iofs8p_sudq_ft_pu (I/O), iofs8p_sudq_ft (I/O), ioms8p_sudq_ft_pd_lv (I/O), ioms8p_sudq_ft_pu_lv (I/O), ioms8p_sudq_ft_lv (I/O), ioms8p_sudq_ft_pd (I/O), ioms8p_sudq_ft_pu (I/O), ioms8p_sudq_ft (I/O), iohs8p_sudq_ft_pd_lv (I/O), iohs8p_sudq_ft_pu_lv (I/O), iohs8p_sudq_ft_lv (I/O), iohs8p_sudq_ft_pd (I/O), iohs8p_sudq_ft_pu (I/O), iohs8p_sudq_ft (I/O), io8prog_1v8_i2c_pd (I/O), io8prog_1v8_i2c_pu (I/O), io8prog_1v8_i2c (I/O), io8prog_3v3_i2c_pd (I/O), io8prog_3v3_i2c_pu (I/O), io8prog_3v3_i2c (I/O), io8ls_1v8_pd (I/O), io8ls_1v8_pu (I/O), io8ls_1v8 (I/O), io8ls_3v3_pd (I/O), io8ls_3v3_pu (I/O), io8ls_3v3 (I/O), io8fs_1v8_pd (I/O), io8fs_1v8_pu (I/O), io8fs_1v8 (I/O), io8fs_3v3_pd (I/O), io8fs_3v3_pu (I/O), io8fs_3v3 (I/O), io8ms_1v8_pd (I/O), io8ms_1v8_pu (I/O), io8ms_1v8 (I/O), io8ms_3v3_pd (I/O), io8ms_3v3_pu (I/O), io8ms_3v3 (I/O), io8hs_1v8_pd (I/O), io8hs_1v8_pu (I/O), io8hs_1v8 (I/O), io8hs_3v3_pd (I/O), io8hs_3v3_pu (I/O), io8hs_3v3 (I/O), usb_ls_pd (I/O), usb_ls_pu2 (I/O), usb_ls_pu (I/O), usb_fs (I/O), usb_fs_pd (I/O), usb_fs_pu2 (I/O), usb_fs_pu (I/O), ioreset_1v2_pu (I/O_open_drain), ioreset_1v2 (I/O_open_drain), ioreset_1v8_pu (I/O_open_drain), ioreset_1v8 (I/O_open_drain), ioreset_3v3_pu (I/O_open_drain), ioreset_3v3 (I/O_open_drain)
