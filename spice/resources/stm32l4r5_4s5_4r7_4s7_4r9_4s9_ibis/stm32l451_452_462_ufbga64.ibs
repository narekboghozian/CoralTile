|   IBIS file stm32l451_452_462_ufbga64.ibs
[IBIS ver]   4.2
[File name]   stm32l451_452_462_ufbga64.ibs
[File Rev]   2.0
[Date]   08-10-2018
[Source]   Data Created at STMicroelectronics
[Disclaimer]  This information is for modeling purpose only and is
   not guaranteed.
   The information is subject to change without notice.
[Copyright]   Copyright 2018 STMicroelectronics Inc.
|   Component stm32l451_452_462_ufbga64
[Component] stm32l451_452_462_ufbga64
[Manufacturer] STMicroelectronics
[Package]
| variable   typ   min   max
R_pkg   0.0   0.0   0.0
L_pkg   0.0H   0.0H   0.0H
C_pkg   0.0F   0.0F   0.0F
[Pin]  signal_name   model_name   R_pin   L_pin   C_pin
A1 PC14-OSC32_IN io8prog2m25m50m120m_sudq_ft
A2 PC13 io8prog2m25m50m120m_sudq_ft
A3 PB9 io8prog2m25m50m120m_sudq_i2c_ft
A4 PB4 io8prog2m25m50m120m_sudq_i2c_ft
A5 PB3 io8prog2m25m50m120m_sudq_ft
A6 PA15 io8prog2m25m50m120m_sudq_ft
A7 PA14 io8prog2m25m50m120m_sudq_ft
A8 PA13 io8prog2m25m50m120m_sudq_ft
B1 PC15-OSC32_OUT io8prog2m25m50m120m_sudq_ft
B2 VBAT POWER
B3 PB8 io8prog2m25m50m120m_sudq_i2c_ft
B4 PH3-BOOT0 io8prog2m25m50m120m_sudq_ft
B5 PD2 io8prog2m25m50m120m_sudq_ft
B6 PC11 io8prog2m25m50m120m_sudq_ft
B7 PC10 io8prog2m25m50m120m_sudq_ft
B8 PA12 io8usb_id_otg20_lcd4_ft_ms
C1 PH0-OSC_IN io8prog2m25m50m120m_sudq_ft
C2 VSS GND
C3 PB7 io8prog2m25m50m120m_sudq_i2c_ft
C4 PB5 io8prog2m25m50m120m_sudq_ft
C5 PC12 io8prog2m25m50m120m_sudq_ft
C6 PA10 io8prog2m25m50m120m_sudq_i2c_ft
C7 PA9 io8prog2m25m50m120m_sudq_i2c_ft
C8 PA11 io8usb_id_otg20_lcd4_ft_ms
D1 PH1-OSC_OUT io8prog2m25m50m120m_sudq_ft
D2 VDD POWER
D3 PB6 io8prog2m25m50m120m_sudq_i2c_ft
D4 VSS GND
D5 VSS GND
D6 VSS GND
D7 PA8 io8prog2m25m50m120m_sudq_ft
D8 PC9 io8prog2m25m50m120m_sudq_ft
E1 NRST ioreset_ft_v33
E2 PC1 io8prog2m25m50m120m_sudq_i2c_ft
E3 PC0 io8prog2m25m50m120m_sudq_i2c_ft
E4 VDD POWER
E5 VDD/VDDUSB POWER
E6 VDD POWER
E7 PC7 io8prog2m25m50m120m_sudq_ft
E8 PC8 io8prog2m25m50m120m_sudq_ft
F1 VSSA_VREF- GND
F2 PC2 io8prog2m25m50m120m_sudq_ft
F3 PA2 io8prog2m25m50m120m_sudq_ft
F4 PA5 io8prog2m25m50m120m_sudq_ft
F5 PB0 io8prog2m25m50m120m_sudq_ft
F6 PC6 io8prog2m25m50m120m_sudq_ft
F7 PB15 io8prog2m25m50m120m_sudq_ft
F8 PB14 io8prog2m25m50m120m_sudq_i2c_ft
G1 PC3 io8prog2m25m50m120m_sudq_ft
G2 PA0 io8prog2m25m50m120m_sudq_ft
G3 PA3 io8prog2m25m50m120m_sudq_ft
G4 PA6 io8prog2m25m50m120m_sudq_ft
G5 PB1 io8prog2m25m50m120m_sudq_ft
G6 PB2 io8prog2m25m50m120m_sudq_ft
G7 PB10 io8prog2m25m50m120m_sudq_i2c_ft
G8 PB13 io8prog2m25m50m120m_sudq_i2c_ft
H1 VDDA_VREF+ POWER
H2 PA1 io8prog2m25m50m120m_sudq_ft
H3 PA4 io8prog2m25m50m120m_sudq_ft
H4 PA7 io8prog2m25m50m120m_sudq_i2c_ft
H5 PC4 io8prog2m25m50m120m_sudq_ft
H6 PC5 io8prog2m25m50m120m_sudq_ft
H7 PB11 io8prog2m25m50m120m_sudq_i2c_ft
H8 PB12 io8prog2m25m50m120m_sudq_ft
[Model Selector] io8prog2m25m50m120m_sudq_ft
iols8p_sudq_ft_pd_lv  "IO low speed, PD=40kOhm - 1P8V"
iols8p_sudq_ft_pu_lv  "IO low speed, PU=40kOhm - 1P8V"
iols8p_sudq_ft_lv  "IO low speed - 1P8V"
iols8p_sudq_ft_pd  "IO low speed, PD=40kOhm - 3P3V"
iols8p_sudq_ft_pu  "IO low speed, PU=40kOhm - 3P3V"
iols8p_sudq_ft  "IO low speed - 3P3V"
iofs8p_sudq_ft_pd_lv  "IO full speed, PD=40kOhm - 1P8V"
iofs8p_sudq_ft_pu_lv  "IO full speed, PU=40kOhm - 1P8V"
iofs8p_sudq_ft_lv  "IO full speed - 1P8V"
iofs8p_sudq_ft_pd  "IO full speed, PD=40kOhm - 3P3V"
iofs8p_sudq_ft_pu  "IO full speed, PU=40kOhm - 3P3V"
iofs8p_sudq_ft  "IO full speed - 3P3V"
ioms8p_sudq_ft_pd_lv  "IO medium speed, PD=40kOhm - 1P8V"
ioms8p_sudq_ft_pu_lv  "IO medium speed, PU=40kOhm - 1P8V"
ioms8p_sudq_ft_lv  "IO medium speed - 1P8V"
ioms8p_sudq_ft_pd  "IO medium speed, PD=40kOhm - 3P3V"
ioms8p_sudq_ft_pu  "IO medium speed, PU=40kOhm - 3P3V"
ioms8p_sudq_ft  "IO medium speed - 3P3V"
iohs8p_sudq_ft_pd_lv  "IO high speed, PD=40kOhm - 1P8V"
iohs8p_sudq_ft_pu_lv  "IO high speed, PU=40kOhm - 1P8V"
iohs8p_sudq_ft_lv  "IO high speed - 1P8V"
iohs8p_sudq_ft_pd  "IO high speed, PD=40kOhm - 3P3V"
iohs8p_sudq_ft_pu  "IO high speed, PU=40kOhm - 3P3V"
iohs8p_sudq_ft  "IO high speed - 3P3V"
[Model Selector] io8usb_id_otg20_lcd4_ft_ms
io8usbid_1v8_id_pu  "ID 1V8 range with pull up"
io8usbid_3v3_id_pu  "ID 3V3 range with pull up"
io8usbid_1v8_id  "ID 1V8 range"
io8usbid_3v3_id  "ID 3V3 range"
io8lsusbid_1v8_pd  "GPIO 1.8V range with pd io low speed"
io8lsusbid_1v8_pu  "GPIO 1.8V range with pu io low speed"
io8lsusbid_1v8  "GPIO 1.8V range io low speed"
io8lsusbid_3v3_pd  "GPIO 3.3V range with pd io low speed"
io8lsusbid_3v3_pu  "GPIO 3.3V range with pu io low speed"
io8lsusbid_3v3  "GPIO 3.3V range io low speed"
io8fsusbid_1v8_pd  "GPIO 1.8V range with pd io full speed"
io8fsusbid_1v8_pu  "GPIO 1.8V range with pu io full speed"
io8fsusbid_1v8  "GPIO 1.8V range io full speed"
io8fsusbid_3v3_pd  "GPIO 3.3V range with pd io full speed"
io8fsusbid_3v3_pu  "GPIO 3.3V range with pu io full speed"
io8fsusbid_3v3  "GPIO 3.3V range io full speed"
io8msusbid_1v8_pd  "GPIO 1.8V range with pd io medium speed"
io8msusbid_1v8_pu  "GPIO 1.8V range with pu io medium speed"
io8msusbid_1v8  "GPIO 1.8V range io medium speed"
io8msusbid_3v3_pd  "GPIO 3.3V range with pd io medium speed"
io8msusbid_3v3_pu  "GPIO 3.3V range with pu io medium speed"
io8msusbid_3v3  "GPIO 3.3V range io medium speed"
io8hsusbid_1v8_pd  "GPIO 1.8V range with pd io high speed"
io8hsusbid_1v8_pu  "GPIO 1.8V range with pu io high speed"
io8hsusbid_1v8  "GPIO 1.8V range io high speed"
io8hsusbid_3v3_pd  "GPIO 3.3V range with pd io high speed"
io8hsusbid_3v3_pu  "GPIO 3.3V range with pu io high speed"
io8hsusbid_3v3  "GPIO 3.3V range io high speed"
[Model Selector] io8prog2m25m50m120m_sudq_i2c_ft
io8prog_1v8_i2c_pd  "5V Tol GPIO 1.8V range i2c functionality with pull down"
io8prog_1v8_i2c_pu  "5V Tol GPIO 1.8V range i2c functionality with pull up"
io8prog_1v8_i2c  "5V Tol GPIO 1.8V range i2c functionality"
io8prog_3v3_i2c_pd  "5V Tol GPIO 3.3V range i2c functionality with pull down"
io8prog_3v3_i2c_pu  "5V Tol GPIO 3.3V range i2c functionality with pull up"
io8prog_3v3_i2c  "5V Tol GPIO 3.3V range i2c functionality"
io8ls_1v8_pd  "5V Tol GPIO 1.8V range with pd io low speed"
io8ls_1v8_pu  "5V Tol GPIO 1.8V range with pu io low speed"
io8ls_1v8  "5V Tol GPIO 1.8V range io low speed"
io8ls_3v3_pd  "5V Tol GPIO 3.3V range with pd io low speed"
io8ls_3v3_pu  "5V Tol GPIO 3.3V range with pu io low speed"
io8ls_3v3  "5V Tol GPIO 3.3V range io low speed"
io8fs_1v8_pd  "5V Tol GPIO 1.8V range with pd io full speed"
io8fs_1v8_pu  "5V Tol GPIO 1.8V range with pu io full speed"
io8fs_1v8  "5V Tol GPIO 1.8V range io full speed"
io8fs_3v3_pd  "5V Tol GPIO 3.3V range with pd io full speed"
io8fs_3v3_pu  "5V Tol GPIO 3.3V range with pu io full speed"
io8fs_3v3  "5V Tol GPIO 3.3V range io full speed"
io8ms_1v8_pd  "5V Tol GPIO 1.8V range with pd io medium speed"
io8ms_1v8_pu  "5V Tol GPIO 1.8V range with pu io medium speed"
io8ms_1v8  "5V Tol GPIO 1.8V range io medium speed"
io8ms_3v3_pd  "5V Tol GPIO 3.3V range with pd io medium speed"
io8ms_3v3_pu  "5V Tol GPIO 3.3V range with pu io medium speed"
io8ms_3v3  "5V Tol GPIO 3.3V range io medium speed"
io8hs_1v8_pd  "5V Tol GPIO 1.8V range with pd io high speed"
io8hs_1v8_pu  "5V Tol GPIO 1.8V range with pu io high speed"
io8hs_1v8  "5V Tol GPIO 1.8V range io high speed"
io8hs_3v3_pd  "5V Tol GPIO 3.3V range with pd io high speed"
io8hs_3v3_pu  "5V Tol GPIO 3.3V range with pu io high speed"
io8hs_3v3  "5V Tol GPIO 3.3V range io high speed"
[Model Selector] ioreset_ft_v33
ioreset_1v2_pu  "RESET 1.2V range with PU"
ioreset_1v2  "RESET 1.2V range"
ioreset_1v8_pu  "RESET 1.8V range with PU"
ioreset_1v8  "RESET 1.8V range"
ioreset_3v3_pu  "RESET 3.3V range with PU"
ioreset_3v3  "RESET 3.3V range"
| Models and submodels in the file (88): iols8p_sudq_ft_pd_lv (I/O), iols8p_sudq_ft_pu_lv (I/O), iols8p_sudq_ft_lv (I/O), iols8p_sudq_ft_pd (I/O), iols8p_sudq_ft_pu (I/O), iols8p_sudq_ft (I/O), iofs8p_sudq_ft_pd_lv (I/O), iofs8p_sudq_ft_pu_lv (I/O), iofs8p_sudq_ft_lv (I/O), iofs8p_sudq_ft_pd (I/O), iofs8p_sudq_ft_pu (I/O), iofs8p_sudq_ft (I/O), ioms8p_sudq_ft_pd_lv (I/O), ioms8p_sudq_ft_pu_lv (I/O), ioms8p_sudq_ft_lv (I/O), ioms8p_sudq_ft_pd (I/O), ioms8p_sudq_ft_pu (I/O), ioms8p_sudq_ft (I/O), iohs8p_sudq_ft_pd_lv (I/O), iohs8p_sudq_ft_pu_lv (I/O), iohs8p_sudq_ft_lv (I/O), iohs8p_sudq_ft_pd (I/O), iohs8p_sudq_ft_pu (I/O), iohs8p_sudq_ft (I/O), io8usbid_1v8_id_pu (Input), io8usbid_3v3_id_pu (Input), io8usbid_1v8_id (Input), io8usbid_3v3_id (Input), io8lsusbid_1v8_pd (I/O), io8lsusbid_1v8_pu (I/O), io8lsusbid_1v8 (I/O), io8lsusbid_3v3_pd (I/O), io8lsusbid_3v3_pu (I/O), io8lsusbid_3v3 (I/O), io8fsusbid_1v8_pd (I/O), io8fsusbid_1v8_pu (I/O), io8fsusbid_1v8 (I/O), io8fsusbid_3v3_pd (I/O), io8fsusbid_3v3_pu (I/O), io8fsusbid_3v3 (I/O), io8msusbid_1v8_pd (I/O), io8msusbid_1v8_pu (I/O), io8msusbid_1v8 (I/O), io8msusbid_3v3_pd (I/O), io8msusbid_3v3_pu (I/O), io8msusbid_3v3 (I/O), io8hsusbid_1v8_pd (I/O), io8hsusbid_1v8_pu (I/O), io8hsusbid_1v8 (I/O), io8hsusbid_3v3_pd (I/O), io8hsusbid_3v3_pu (I/O), io8hsusbid_3v3 (I/O), io8prog_1v8_i2c_pd (I/O), io8prog_1v8_i2c_pu (I/O), io8prog_1v8_i2c (I/O), io8prog_3v3_i2c_pd (I/O), io8prog_3v3_i2c_pu (I/O), io8prog_3v3_i2c (I/O), io8ls_1v8_pd (I/O), io8ls_1v8_pu (I/O), io8ls_1v8 (I/O), io8ls_3v3_pd (I/O), io8ls_3v3_pu (I/O), io8ls_3v3 (I/O), io8fs_1v8_pd (I/O), io8fs_1v8_pu (I/O), io8fs_1v8 (I/O), io8fs_3v3_pd (I/O), io8fs_3v3_pu (I/O), io8fs_3v3 (I/O), io8ms_1v8_pd (I/O), io8ms_1v8_pu (I/O), io8ms_1v8 (I/O), io8ms_3v3_pd (I/O), io8ms_3v3_pu (I/O), io8ms_3v3 (I/O), io8hs_1v8_pd (I/O), io8hs_1v8_pu (I/O), io8hs_1v8 (I/O), io8hs_3v3_pd (I/O)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
