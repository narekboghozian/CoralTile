|   IBIS file stm32l412_422_lqfp32.ibs
[IBIS ver]   4.2
[File name]   stm32l412_422_lqfp32.ibs
[File Rev]   1.0
[Date]   08-10-2018
[Source]   Data Created at STMicroelectronics
[Notes]   File originated from ELDO simulations.
[Disclaimer]  This information is for modeling purpose only and is
   not guaranteed.
   The information is subject to change without notice.
[Copyright]   Copyright 2018 STMicroelectronics Inc.
|   Component stm32l412_422_lqfp32
[Component] stm32l412_422_lqfp32
[Manufacturer] STMicroelectronics
[Package]
| variable   typ   min   max
R_pkg   0   0   0
L_pkg   0   0   0
C_pkg   0   0   0
[Pin]   signal_name   model_name   R_pin   L_pin   C_pin
1 VDD POWER 64.896E-3 2.0240E-9 16.235E-15
2 PC14-OSC32_IN io8prog2m25m50m120m_sudq_ft 54.988E-3 1.7405E-9 14.587E-15
3 PC15-OSC32_OUT io8prog2m25m50m120m_sudq_ft 53.017E-3 1.6595E-9 8.197E-15
4 NRST ioreset_ft_v33 54.033E-3 1.6554E-9 7.363E-15
5 VDDA/VREF+ POWER 56.223E-3 1.7156E-9 10.783E-15
6 PA0-CK_IN io8prog2m25m50m120m_sudq_ft 61.160E-3 1.8629E-9 10.243E-15
7 PA1 io8prog2m25m50m120m_sudq_ft 59.987E-3 1.8648E-9 10.852E-15
8 PA2 io8prog2m25m50m120m_sudq_ft 71.192E-3 2.1932E-9 17.019E-15
9 PA3 io8prog2m25m50m120m_sudq_ft 71.059E-3 2.1776E-9 16.855E-15
10 PA4 io8prog2m25m50m120m_sudq_ft 63.005E-3 1.9478E-9 14.439E-15
11 PA5 io8prog2m25m50m120m_sudq_ft 58.243E-3 1.7981E-9 7.948E-15
12 PA6 io8prog2m25m50m120m_sudq_ft 55.874E-3 1.7092E-9 8.812E-15
13 PA7 io8prog2m25m50m120m_sudq_i2c_ft 55.141E-3 1.6964E-9 12.212E-15
14 PB0 io8prog2m25m50m120m_sudq_ft 56.661E-3 1.7554E-9 4.706E-15
15 PB1 io8prog2m25m50m120m_sudq_ft 61.182E-3 1.8979E-9 13.557E-15
16 VSS GND 68.639E-3 2.1172E-9 16.500E-15
17 VDD POWER 66.539E-3 2.0692E-9 17.677E-15
18 PA8 isudqf_ft_v33 71.158E-3 2.1438E-9 11.062E-15
19 PA9 io8prog2m25m50m120m_sudq_i2c_ft 63.842E-3 1.9327E-9 9.196E-15
20 PA10 io8prog2m25m50m120m_sudq_i2c_ft 58.291E-3 1.7635E-9 11.677E-15
21 PA11 io8usblsfs_otg2 54.700E-3 1.6700E-9 6.891E-15
22 PA12 io8usblsfs_otg2 53.046E-3 1.6525E-9 10.905E-15
23 PA13 io8prog2m25m50m120m_sudq_ft 62.866E-3 1.9450E-9 11.111E-15
24 PA14 io8prog2m25m50m120m_sudq_ft 75.711E-3 2.3060E-9 17.278E-15
25 PA15 io8prog2m25m50m120m_sudq_ft 74.224E-3 2.2583E-9 19.736E-15
26 PB3 io8prog2m25m50m120m_sudq_ft 65.224E-3 2.0006E-9 8.439E-15
27 PB4 io8prog2m25m50m120m_sudq_i2c_ft 59.281E-3 1.8183E-9 10.281E-15
28 PB5 io8prog2m25m50m120m_sudq_ft 56.029E-3 1.7169E-9 8.461E-15
29 PB6 io8prog2m25m50m120m_sudq_i2c_ft 55.139E-3 1.6969E-9 12.383E-15
30 PB7 io8prog2m25m50m120m_sudq_i2c_ft 56.372E-3 1.7463E-9 4.202E-15
31 PH3-BOOT0 io8prog2m25m50m120m_sudq_ft 59.845E-3 1.8672E-9 13.676E-15
32 VSS GND 66.777E-3 2.0705E-9 14.725E-15
[Model Selector] io8prog2m25m50m120m_sudq_ft
iols8p_sudq_ft_pd_lv  "IO low speed, PD=40kOhm - 1P8V"
iols8p_sudq_ft_pu_lv  "IO low speed, PU=40kOhm - 1P8V"
iols8p_sudq_ft_lv  "IO low speed - 1P8V"
iols8p_sudq_ft_pd  "IO low speed, PD=40kOhm - 3P3V"
iols8p_sudq_ft_pu  "IO low speed, PU=40kOhm - 3P3V"
iols8p_sudq_ft  "IO low speed - 3P3V"
iofs8p_sudq_ft_pd_lv  "IO full speed, PD=40kOhm - 1P8V"
iofs8p_sudq_ft_pu_lv  "IO full speed, PU=40kOhm - 1P8V"
iofs8p_sudq_ft_lv  "IO full speed - 1P8V"
iofs8p_sudq_ft_pd  "IO full speed, PD=40kOhm - 3P3V"
iofs8p_sudq_ft_pu  "IO full speed, PU=40kOhm - 3P3V"
iofs8p_sudq_ft  "IO full speed - 3P3V"
ioms8p_sudq_ft_pd_lv  "IO medium speed, PD=40kOhm - 1P8V"
ioms8p_sudq_ft_pu_lv  "IO medium speed, PU=40kOhm - 1P8V"
ioms8p_sudq_ft_lv  "IO medium speed - 1P8V"
ioms8p_sudq_ft_pd  "IO medium speed, PD=40kOhm - 3P3V"
ioms8p_sudq_ft_pu  "IO medium speed, PU=40kOhm - 3P3V"
ioms8p_sudq_ft  "IO medium speed - 3P3V"
iohs8p_sudq_ft_pd_lv  "IO high speed, PD=40kOhm - 1P8V"
iohs8p_sudq_ft_pu_lv  "IO high speed, PU=40kOhm - 1P8V"
iohs8p_sudq_ft_lv  "IO high speed - 1P8V"
iohs8p_sudq_ft_pd  "IO high speed, PD=40kOhm - 3P3V"
iohs8p_sudq_ft_pu  "IO high speed, PU=40kOhm - 3P3V"
iohs8p_sudq_ft  "IO high speed - 3P3V"
[Model Selector] io8prog2m25m50m120m_sudq_i2c_ft
io8prog_1v8_i2c_pd  "5V Tol GPIO 1.8V range i2c functionality with pull down"
io8prog_1v8_i2c_pu  "5V Tol GPIO 1.8V range i2c functionality with pull up"
io8prog_1v8_i2c  "5V Tol GPIO 1.8V range i2c functionality"
io8prog_3v3_i2c_pd  "5V Tol GPIO 3.3V range i2c functionality with pull down"
io8prog_3v3_i2c_pu  "5V Tol GPIO 3.3V range i2c functionality with pull up"
io8prog_3v3_i2c  "5V Tol GPIO 3.3V range i2c functionality"
io8ls_1v8_pd  "5V Tol GPIO 1.8V range with pd io low speed"
io8ls_1v8_pu  "5V Tol GPIO 1.8V range with pu io low speed"
io8ls_1v8  "5V Tol GPIO 1.8V range io low speed"
io8ls_3v3_pd  "5V Tol GPIO 3.3V range with pd io low speed"
io8ls_3v3_pu  "5V Tol GPIO 3.3V range with pu io low speed"
io8ls_3v3  "5V Tol GPIO 3.3V range io low speed"
io8fs_1v8_pd  "5V Tol GPIO 1.8V range with pd io full speed"
io8fs_1v8_pu  "5V Tol GPIO 1.8V range with pu io full speed"
io8fs_1v8  "5V Tol GPIO 1.8V range io full speed"
io8fs_3v3_pd  "5V Tol GPIO 3.3V range with pd io full speed"
io8fs_3v3_pu  "5V Tol GPIO 3.3V range with pu io full speed"
io8fs_3v3  "5V Tol GPIO 3.3V range io full speed"
io8ms_1v8_pd  "5V Tol GPIO 1.8V range with pd io medium speed"
io8ms_1v8_pu  "5V Tol GPIO 1.8V range with pu io medium speed"
io8ms_1v8  "5V Tol GPIO 1.8V range io medium speed"
io8ms_3v3_pd  "5V Tol GPIO 3.3V range with pd io medium speed"
io8ms_3v3_pu  "5V Tol GPIO 3.3V range with pu io medium speed"
io8ms_3v3  "5V Tol GPIO 3.3V range io medium speed"
io8hs_1v8_pd  "5V Tol GPIO 1.8V range with pd io high speed"
io8hs_1v8_pu  "5V Tol GPIO 1.8V range with pu io high speed"
io8hs_1v8  "5V Tol GPIO 1.8V range io high speed"
io8hs_3v3_pd  "5V Tol GPIO 3.3V range with pd io high speed"
io8hs_3v3_pu  "5V Tol GPIO 3.3V range with pu io high speed"
io8hs_3v3  "5V Tol GPIO 3.3V range io high speed"
[Model Selector] io8usblsfs_otg2
usb_ls_pd  "USB Low Speed mode - Pull Down"
usb_ls_pu2  "USB Low Speed mode - Pull up 2"
usb_ls_pu  "USB Low Speed mode - Pull up"
usb_fs  "USB Low Speed mode"
usb_fs_pd  "USB Full Speed mode - Pull Down"
usb_fs_pu2  "USB Full Speed mode - Pull up 2"
usb_fs_pu  "USB Full Speed mode - Pull up"
[Model Selector] ioreset_ft_v33
ioreset_1v2_pu  "RESET 1.2V range with PU"
ioreset_1v2  "RESET 1.2V range"
ioreset_1v8_pu  "RESET 1.8V range with PU"
ioreset_1v8  "RESET 1.8V range"
ioreset_3v3_pu  "RESET 3.3V range with PU"
ioreset_3v3  "RESET 3.3V range"
[Model Selector] isudqf_ft_v33
in_ft_v33_pd  "GP Input. 5V tolerant. 3.3V range with pull down"
in_ft_v33_pu  "GP Input. 5V tolerant. 3.3V range with pull up"
in_ft_v33  "GP Input. 5V tolerant. 3.3V range"
| Models and submodels in the file (70): iols8p_sudq_ft_pd_lv (I/O), iols8p_sudq_ft_pu_lv (I/O), iols8p_sudq_ft_lv (I/O), iols8p_sudq_ft_pd (I/O), iols8p_sudq_ft_pu (I/O), iols8p_sudq_ft (I/O), iofs8p_sudq_ft_pd_lv (I/O), iofs8p_sudq_ft_pu_lv (I/O), iofs8p_sudq_ft_lv (I/O), iofs8p_sudq_ft_pd (I/O), iofs8p_sudq_ft_pu (I/O), iofs8p_sudq_ft (I/O), ioms8p_sudq_ft_pd_lv (I/O), ioms8p_sudq_ft_pu_lv (I/O), ioms8p_sudq_ft_lv (I/O), ioms8p_sudq_ft_pd (I/O), ioms8p_sudq_ft_pu (I/O), ioms8p_sudq_ft (I/O), iohs8p_sudq_ft_pd_lv (I/O), iohs8p_sudq_ft_pu_lv (I/O), iohs8p_sudq_ft_lv (I/O), iohs8p_sudq_ft_pd (I/O), iohs8p_sudq_ft_pu (I/O), iohs8p_sudq_ft (I/O), io8prog_1v8_i2c_pd (I/O), io8prog_1v8_i2c_pu (I/O), io8prog_1v8_i2c (I/O), io8prog_3v3_i2c_pd (I/O), io8prog_3v3_i2c_pu (I/O), io8prog_3v3_i2c (I/O), io8ls_1v8_pd (I/O), io8ls_1v8_pu (I/O), io8ls_1v8 (I/O), io8ls_3v3_pd (I/O), io8ls_3v3_pu (I/O), io8ls_3v3 (I/O), io8fs_1v8_pd (I/O), io8fs_1v8_pu (I/O), io8fs_1v8 (I/O), io8fs_3v3_pd (I/O), io8fs_3v3_pu (I/O), io8fs_3v3 (I/O), io8ms_1v8_pd (I/O), io8ms_1v8_pu (I/O), io8ms_1v8 (I/O), io8ms_3v3_pd (I/O), io8ms_3v3_pu (I/O), io8ms_3v3 (I/O), io8hs_1v8_pd (I/O), io8hs_1v8_pu (I/O), io8hs_1v8 (I/O), io8hs_3v3_pd (I/O), io8hs_3v3_pu (I/O), io8hs_3v3 (I/O), usb_ls_pd (I/O), usb_ls_pu2 (I/O), usb_ls_pu (I/O), usb_fs (I/O), usb_fs_pd (I/O), usb_fs_pu2 (I/O), usb_fs_pu (I/O), ioreset_1v2_pu (I/O_open_drain), ioreset_1v2 (I/O_open_drain), ioreset_1v8_pu (I/O_open_drain), ioreset_1v8 (I/O_open_drain), ioreset_3v3_pu (I/O_open_drain), ioreset_3v3 (I/O_open_drain), in_ft_v33_pd (Input), in_ft_v33_pu (Input), in_ft_v33 (Input)
