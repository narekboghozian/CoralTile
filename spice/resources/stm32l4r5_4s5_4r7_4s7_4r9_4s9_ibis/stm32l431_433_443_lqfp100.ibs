|   IBIS file stm32l431_433_443_lqfp100.ibs
[IBIS ver]   4.2
[File name]   stm32l431_433_443_lqfp100.ibs
[File Rev]   4.0
[Date]   08-10-2018
[Source]   Data Created at STMicroelectronics
[Notes]   File originated from ELDO simulations.
[Disclaimer]  This information is for modeling purpose only and is
   not guaranteed.
   The information is subject to change without notice.
[Copyright]   Copyright 2018 STMicroelectronics Inc.
|   Component stm32l431_433_443_lqfp100
[Component] stm32l431_433_443_lqfp100
[Manufacturer] STMicroelectronics
[Package]
| variable   typ   min   max
R_pkg   0.0   0.0   0.0
L_pkg   0.0H   0.0H   0.0H
C_pkg   0.0F   0.0F   0.0F
[Pin]  signal_name   model_name   R_pin   L_pin   C_pin
1 PE2 io8prog2m25m50m120m_sudq_ft 132.430E-3 7.034E-9 135.000E-15
2 PE3 io8prog2m25m50m120m_sudq_ft 133.348E-3 6.765E-9 19.500E-15
3 PE4 io8prog2m25m50m120m_sudq_ft 128.973E-3 6.495E-9 10.400E-15
4 PE5 io8prog2m25m50m120m_sudq_ft 125.345E-3 6.206E-9 5.240E-15
5 PE6 io8prog2m25m50m120m_sudq_ft 120.515E-3 5.991E-9 7.820E-15
6 VBAT POWER 120.471E-3 5.950E-9 6.530E-15
7 PC13 io8prog2m25m50m120m_sudq_ft 117.881E-3 5.783E-9 6.230E-15
8 PC14-OSC32_IN io8prog2m25m50m120m_sudq_ft 117.279E-3 5.654E-9 3.110E-15
9 PC15-OSC32_OUT io8prog2m25m50m120m_sudq_ft 115.548E-3 5.548E-9 1.390E-15
10 VSS GND 114.996E-3 5.434E-9 2.920E-15
11 VDD POWER 112.976E-3 5.296E-9 3.560E-15
12 PH0-OSC_IN io8prog2m25m50m120m_sudq_ft 111.323E-3 5.231E-9 4.780E-15
13 PH1-OSC_OUT io8prog2m25m50m120m_sudq_ft 109.217E-3 5.142E-9 8.660E-15
14 NRST ioreset_ft_v33 110.664E-3 5.180E-9 9.030E-15
15 PC0 io8prog2m25m50m120m_sudq_i2c_ft 110.608E-3 5.192E-9 7.980E-15
16 PC1 io8prog2m25m50m120m_sudq_i2c_ft 111.326E-3 5.252E-9 10.300E-15
17 PC2 io8prog2m25m50m120m_sudq_ft 114.420E-3 5.345E-9 7.000E-15
18 PC3 io8prog2m25m50m120m_sudq_ft 114.363E-3 5.454E-9 8.650E-15
19 VSSA GND 117.564E-3 5.621E-9 7.825E-15
20 VREF- GND 119.905E-3 5.800E-9 229.000E-18
21 VREF+ POWER 122.312E-3 5.963E-9 1.050E-15
22 VDDA POWER 125.384E-3 6.187E-9 812.000E-18
23 PA0 io8prog2m25m50m120m_sudq_ft 129.702E-3 6.485E-9 3.820E-15
24 PA1 io8prog2m25m50m120m_sudq_ft 132.290E-3 6.715E-9 6.800E-15
25 PA2 io8prog2m25m50m120m_sudq_ft 132.955E-3 7.014E-9 16.700E-15
26 PA3 io8prog2m25m50m120m_sudq_ft 133.943E-3 7.050E-9 17.500E-15
27 VSS GND 134.958E-3 6.804E-9 12.700E-15
28 VDD POWER 130.511E-3 6.528E-9 9.830E-15
29 PA4 io8prog2m25m50m120m_sudq_ft 125.387E-3 6.245E-9 6.070E-15
30 PA5 io8prog2m25m50m120m_sudq_ft 124.989E-3 6.108E-9 577.000E-18
31 PA6 io8prog2m25m50m120m_sudq_ft 121.784E-3 5.890E-9 1.520E-15
32 PA7 io8prog2m25m50m120m_sudq_i2c_ft 119.149E-3 5.716E-9 5.440E-15
33 PC4 io8prog2m25m50m120m_sudq_ft 116.375E-3 5.556E-9 4.100E-15
34 PC5 io8prog2m25m50m120m_sudq_ft 113.279E-3 5.415E-9 3.690E-15
35 PB0 io8prog2m25m50m120m_sudq_ft 112.727E-3 5.358E-9 3.895E-15
36 PB1 io8prog2m25m50m120m_sudq_ft 112.271E-3 5.272E-9 1.660E-15
37 PB2 io8prog2m25m50m120m_sudq_ft 111.816E-3 5.238E-9 7.920E-15
38 PE7 io8prog2m25m50m120m_sudq_ft 110.999E-3 5.184E-9 9.900E-15
39 PE8 io8prog2m25m50m120m_sudq_ft 114.589E-3 5.299E-9 7.910E-15
40 PE9 io8prog2m25m50m120m_sudq_ft 114.461E-3 5.333E-9 7.940E-15
41 PE10 io8prog2m25m50m120m_sudq_ft 115.350E-3 5.424E-9 4.180E-15
42 PE11 io8prog2m25m50m120m_sudq_ft 116.979E-3 5.533E-9 6.060E-15
43 PE12 io8prog2m25m50m120m_sudq_ft 120.185E-3 5.698E-9 5.120E-15
44 PE13 io8prog2m25m50m120m_sudq_ft 122.587E-3 5.871E-9 4.740E-15
45 PE14 io8prog2m25m50m120m_sudq_ft 126.303E-3 6.069E-9 11.600E-15
46 PE15 io8prog2m25m50m120m_sudq_ft 129.715E-3 6.277E-9 9.910E-15
47 PB10 io8prog2m25m50m120m_sudq_i2c_ft 133.373E-3 6.508E-9 5.080E-15
48 PB11 io8prog2m25m50m120m_sudq_i2c_ft 137.888E-3 6.857E-9 5.470E-15
49 VSS GND 131.554E-3 6.802E-9 4.180E-15
50 VDD POWER 132.348E-3 7.042E-9 11.900E-15
51 PB12 io8w_swp_lcd4_ft 131.768E-3 7.008E-9 16.200E-15
52 PB13 io8prog2m25m50m120m_sudq_i2c_ft 131.784E-3 6.751E-9 2.150E-15
53 PB14 io8prog2m25m50m120m_sudq_i2c_ft 129.151E-3 6.483E-9 9.175E-15
54 PB15 io8prog2m25m50m120m_sudq_ft 125.191E-3 6.202E-9 5.663E-15
55 PD8 io8prog2m25m50m120m_sudq_ft 121.530E-3 5.986E-9 3.690E-15
56 PD9 io8prog2m25m50m120m_sudq_ft 118.874E-3 5.807E-9 7.430E-15
57 PD10 io8prog2m25m50m120m_sudq_ft 115.870E-3 5.635E-9 10.600E-15
58 PD11 io8prog2m25m50m120m_sudq_ft 113.226E-3 5.471E-9 5.760E-15
59 PD12 io8prog2m25m50m120m_sudq_ft 111.782E-3 5.354E-9 6.530E-15
60 PD13 io8prog2m25m50m120m_sudq_ft 110.713E-3 5.276E-9 11.400E-15
61 PD14 io8prog2m25m50m120m_sudq_ft 110.052E-3 5.204E-9 13.200E-15
62 PD15 io8prog2m25m50m120m_sudq_ft 109.954E-3 5.180E-9 14.600E-15
63 PC6 io8prog2m25m50m120m_sudq_ft 109.780E-3 5.154E-9 7.250E-15
64 PC7 io8prog2m25m50m120m_sudq_ft 112.446E-3 5.258E-9 359.000E-18
65 PC8 io8prog2m25m50m120m_sudq_ft 113.596E-3 5.332E-9 658.000E-18
66 PC9 io8prog2m25m50m120m_sudq_ft 115.707E-3 5.466E-9 508.500E-18
67 PA8 io8w_swp_lcd4_ft 116.952E-3 5.598E-9 583.250E-18
68 PA9 io8prog2m25m50m120m_sudq_i2c_ft 119.043E-3 5.762E-9 545.875E-18
69 PA10 io8prog2m25m50m120m_sudq_i2c_ft 120.674E-3 5.880E-9 13.900E-15
70 PA11 io8usblsfs_otg2 124.659E-3 6.108E-9 25.000E-15
71 PA12 io8usblsfs_otg2 124.407E-3 6.161E-9 39.900E-15
72 PA13 io8prog2m25m50m120m_sudq_ft 130.156E-3 6.404E-9 302.000E-15
73 VDDUSB/VDD POWER 135.110E-3 6.824E-9 155.000E-15
74 VSS GND 139.402E-3 7.077E-9 155.000E-15
75 VDD POWER 133.554E-3 7.056E-9 39.000E-15
76 PA14 io8prog2m25m50m120m_sudq_ft 135.295E-3 7.104E-9 16.300E-15
77 PA15 io8prog2m25m50m120m_sudq_ft 132.514E-3 6.836E-9 9.760E-15
78 PC10 io8prog2m25m50m120m_sudq_ft 133.482E-3 6.641E-9 9.300E-15
79 PC11 io8prog2m25m50m120m_sudq_ft 128.366E-3 6.341E-9 5.420E-15
80 PC12 io8prog2m25m50m120m_sudq_ft 124.282E-3 6.092E-9 1.180E-15
81 PD0 io8prog2m25m50m120m_sudq_ft 121.841E-3 5.917E-9 5.460E-15
82 PD1 io8prog2m25m50m120m_sudq_ft 118.487E-3 5.728E-9 7.000E-15
83 PD2 io8prog2m25m50m120m_sudq_ft 117.180E-3 5.573E-9 6.060E-15
84 PD3 io8prog2m25m50m120m_sudq_ft 113.501E-3 5.422E-9 5.450E-15
85 PD4 io8prog2m25m50m120m_sudq_ft 113.789E-3 5.344E-9 529.000E-18
86 PD5 io8prog2m25m50m120m_sudq_ft 110.806E-3 5.256E-9 2.990E-15
87 PD6 io8prog2m25m50m120m_sudq_ft 110.442E-3 5.246E-9 2.060E-15
88 PD7 io8prog2m25m50m120m_sudq_ft 111.525E-3 5.178E-9 5.680E-15
89 PB3 io8prog2m25m50m120m_sudq_ft 111.144E-3 5.223E-9 9.910E-15
90 PB4 io8prog2m25m50m120m_sudq_i2c_ft 113.222E-3 5.310E-9 9.050E-15
91 PB5 io8prog2m25m50m120m_sudq_ft 113.323E-3 5.401E-9 12.900E-15
92 PB6 io8prog2m25m50m120m_sudq_i2c_ft 115.849E-3 5.519E-9 12.600E-15
93 PB7 io8prog2m25m50m120m_sudq_i2c_ft 117.578E-3 5.673E-9 6.140E-15
94 PH3 io8prog2m25m50m120m_sudq_ft 118.982E-3 5.802E-9 9.370E-15
95 PB8 io8prog2m25m50m120m_sudq_i2c_ft 121.886E-3 5.962E-9 7.755E-15
96 PB9 io8prog2m25m50m120m_sudq_i2c_ft 126.276E-3 6.158E-9 8.563E-15
97 PE0 io8prog2m25m50m120m_sudq_ft 128.749E-3 6.367E-9 8.159E-15
98 PE1 io8prog2m25m50m120m_sudq_ft 133.288E-3 6.700E-9 1.030E-15
99 VSS GND 132.230E-3 6.844E-9 4.410E-15
100 VDD POWER 132.277E-3 7.052E-9 17.100E-15
[Diff Pin]   inv_pin   vdiff   tdelay_typ  tdelay_min  tdelay_max
70 71 200mV   NA   NA   NA
[Model Selector] io8usblsfs_otg2
usb_ls_pd  "USB Low Speed mode - Pull Down"
usb_ls_pu2  "USB Low Speed mode - Pull up 2"
usb_ls_pu  "USB Low Speed mode - Pull up"
usb_fs  "USB Low Speed mode"
usb_fs_pd  "USB Full Speed mode - Pull Down"
usb_fs_pu2  "USB Full Speed mode - Pull up 2"
usb_fs_pu  "USB Full Speed mode - Pull up"
[Model Selector] io8w_swp_lcd4_ft
io8w_swp_classc  "Class C swp functionality"
io8w_swp_classb  "Class B swp functionality"
io8lsw_1v8_pd  "GPIO 1.8V range with pd io low speed"
io8lsw_1v8_pu  "GPIO 1.8V range with pu io low speed"
io8lsw_1v8  "GPIO 1.8V range io low speed"
io8lsw_3v3_pd  "GPIO 3.3V range with pd io low speed"
io8lsw_3v3_pu  "GPIO 3.3V range with pu io low speed"
io8lsw_3v3  "GPIO 3.3V range io low speed"
io8fsw_1v8_pd  "GPIO 1.8V range with pd io full speed"
io8fsw_1v8_pu  "GPIO 1.8V range with pu io full speed"
io8fsw_1v8  "GPIO 1.8V range io full speed"
io8fsw_3v3_pd  "GPIO 3.3V range with pd io full speed"
io8fsw_3v3_pu  "GPIO 3.3V range with pu io full speed"
io8fsw_3v3  "GPIO 3.3V range io full speed"
io8msw_1v8_pd  "GPIO 1.8V range with pd io medium speed"
io8msw_1v8_pu  "GPIO 1.8V range with pu io medium speed"
io8msw_1v8  "GPIO 1.8V range io medium speed"
io8msw_3v3_pd  "GPIO 3.3V range with pd io medium speed"
io8msw_3v3_pu  "GPIO 3.3V range with pu io medium speed"
io8msw_3v3  "GPIO 3.3V range io medium speed"
io8hsw_1v8_pd  "GPIO 1.8V range with pd io high speed"
io8hsw_1v8_pu  "GPIO 1.8V range with pu io high speed"
io8hsw_1v8  "GPIO 1.8V range io high speed"
io8hsw_3v3_pd  "GPIO 3.3V range with pd io high speed"
io8hsw_3v3_pu  "GPIO 3.3V range with pu io high speed"
io8hsw_3v3  "GPIO 3.3V range io high speed"
[Model Selector] io8prog2m25m50m120m_sudq_ft
iols8p_sudq_ft_pd_lv  "IO low speed, PD=40kOhm - 1P8V"
iols8p_sudq_ft_pu_lv  "IO low speed, PU=40kOhm - 1P8V"
iols8p_sudq_ft_lv  "IO low speed - 1P8V"
iols8p_sudq_ft_pd  "IO low speed, PD=40kOhm - 3P3V"
iols8p_sudq_ft_pu  "IO low speed, PU=40kOhm - 3P3V"
iols8p_sudq_ft  "IO low speed - 3P3V"
iofs8p_sudq_ft_pd_lv  "IO full speed, PD=40kOhm - 1P8V"
iofs8p_sudq_ft_pu_lv  "IO full speed, PU=40kOhm - 1P8V"
iofs8p_sudq_ft_lv  "IO full speed - 1P8V"
iofs8p_sudq_ft_pd  "IO full speed, PD=40kOhm - 3P3V"
iofs8p_sudq_ft_pu  "IO full speed, PU=40kOhm - 3P3V"
iofs8p_sudq_ft  "IO full speed - 3P3V"
ioms8p_sudq_ft_pd_lv  "IO medium speed, PD=40kOhm - 1P8V"
ioms8p_sudq_ft_pu_lv  "IO medium speed, PU=40kOhm - 1P8V"
ioms8p_sudq_ft_lv  "IO medium speed - 1P8V"
ioms8p_sudq_ft_pd  "IO medium speed, PD=40kOhm - 3P3V"
ioms8p_sudq_ft_pu  "IO medium speed, PU=40kOhm - 3P3V"
ioms8p_sudq_ft  "IO medium speed - 3P3V"
iohs8p_sudq_ft_pd_lv  "IO high speed, PD=40kOhm - 1P8V"
iohs8p_sudq_ft_pu_lv  "IO high speed, PU=40kOhm - 1P8V"
iohs8p_sudq_ft_lv  "IO high speed - 1P8V"
iohs8p_sudq_ft_pd  "IO high speed, PD=40kOhm - 3P3V"
iohs8p_sudq_ft_pu  "IO high speed, PU=40kOhm - 3P3V"
iohs8p_sudq_ft  "IO high speed - 3P3V"
[Model Selector] io8prog2m25m50m120m_sudq_i2c_ft
io8prog_1v8_i2c_pd  "5V Tol GPIO 1.8V range i2c functionality with pull down"
io8prog_1v8_i2c_pu  "5V Tol GPIO 1.8V range i2c functionality with pull up"
io8prog_1v8_i2c  "5V Tol GPIO 1.8V range i2c functionality"
io8prog_3v3_i2c_pd  "5V Tol GPIO 3.3V range i2c functionality with pull down"
io8prog_3v3_i2c_pu  "5V Tol GPIO 3.3V range i2c functionality with pull up"
io8prog_3v3_i2c  "5V Tol GPIO 3.3V range i2c functionality"
io8ls_1v8_pd  "5V Tol GPIO 1.8V range with pd io low speed"
io8ls_1v8_pu  "5V Tol GPIO 1.8V range with pu io low speed"
io8ls_1v8  "5V Tol GPIO 1.8V range io low speed"
io8ls_3v3_pd  "5V Tol GPIO 3.3V range with pd io low speed"
io8ls_3v3_pu  "5V Tol GPIO 3.3V range with pu io low speed"
io8ls_3v3  "5V Tol GPIO 3.3V range io low speed"
io8fs_1v8_pd  "5V Tol GPIO 1.8V range with pd io full speed"
io8fs_1v8_pu  "5V Tol GPIO 1.8V range with pu io full speed"
io8fs_1v8  "5V Tol GPIO 1.8V range io full speed"
io8fs_3v3_pd  "5V Tol GPIO 3.3V range with pd io full speed"
io8fs_3v3_pu  "5V Tol GPIO 3.3V range with pu io full speed"
io8fs_3v3  "5V Tol GPIO 3.3V range io full speed"
io8ms_1v8_pd  "5V Tol GPIO 1.8V range with pd io medium speed"
io8ms_1v8_pu  "5V Tol GPIO 1.8V range with pu io medium speed"
io8ms_1v8  "5V Tol GPIO 1.8V range io medium speed"
io8ms_3v3_pd  "5V Tol GPIO 3.3V range with pd io medium speed"
io8ms_3v3_pu  "5V Tol GPIO 3.3V range with pu io medium speed"
io8ms_3v3  "5V Tol GPIO 3.3V range io medium speed"
io8hs_1v8_pd  "5V Tol GPIO 1.8V range with pd io high speed"
io8hs_1v8_pu  "5V Tol GPIO 1.8V range with pu io high speed"
io8hs_1v8  "5V Tol GPIO 1.8V range io high speed"
io8hs_3v3_pd  "5V Tol GPIO 3.3V range with pd io high speed"
io8hs_3v3_pu  "5V Tol GPIO 3.3V range with pu io high speed"
io8hs_3v3  "5V Tol GPIO 3.3V range io high speed"
[Model Selector] ioreset_ft_v33
ioreset_1v2_pu  "RESET 1.2V range with PU"
ioreset_1v2  "RESET 1.2V range"
ioreset_1v8_pu  "RESET 1.8V range with PU"
ioreset_1v8  "RESET 1.8V range"
ioreset_3v3_pu  "RESET 3.3V range with PU"
ioreset_3v3  "RESET 3.3V range"
| Models and submodels in the file (93): usb_ls_pd (I/O), usb_ls_pu2 (I/O), usb_ls_pu (I/O), usb_fs (I/O), usb_fs_pd (I/O), usb_fs_pu2 (I/O), usb_fs_pu (I/O), io8w_swp_classc (I/O), io8w_swp_classb (I/O), io8lsw_1v8_pd (I/O), io8lsw_1v8_pu (I/O), io8lsw_1v8 (I/O), io8lsw_3v3_pd (I/O), io8lsw_3v3_pu (I/O), io8lsw_3v3 (I/O), io8fsw_1v8_pd (I/O), io8fsw_1v8_pu (I/O), io8fsw_1v8 (I/O), io8fsw_3v3_pd (I/O), io8fsw_3v3_pu (I/O), io8fsw_3v3 (I/O), io8msw_1v8_pd (I/O), io8msw_1v8_pu (I/O), io8msw_1v8 (I/O), io8msw_3v3_pd (I/O), io8msw_3v3_pu (I/O), io8msw_3v3 (I/O), io8hsw_1v8_pd (I/O), io8hsw_1v8_pu (I/O), io8hsw_1v8 (I/O), io8hsw_3v3_pd (I/O), io8hsw_3v3_pu (I/O), io8hsw_3v3 (I/O), iols8p_sudq_ft_pd_lv (I/O), iols8p_sudq_ft_pu_lv (I/O), iols8p_sudq_ft_lv (I/O), iols8p_sudq_ft_pd (I/O), iols8p_sudq_ft_pu (I/O), iols8p_sudq_ft (I/O), iofs8p_sudq_ft_pd_lv (I/O), iofs8p_sudq_ft_pu_lv (I/O), iofs8p_sudq_ft_lv (I/O), iofs8p_sudq_ft_pd (I/O), iofs8p_sudq_ft_pu (I/O), iofs8p_sudq_ft (I/O), ioms8p_sudq_ft_pd_lv (I/O), ioms8p_sudq_ft_pu_lv (I/O), ioms8p_sudq_ft_lv (I/O), ioms8p_sudq_ft_pd (I/O), ioms8p_sudq_ft_pu (I/O), ioms8p_sudq_ft (I/O), iohs8p_sudq_ft_pd_lv (I/O), iohs8p_sudq_ft_pu_lv (I/O), iohs8p_sudq_ft_lv (I/O), iohs8p_sudq_ft_pd (I/O), iohs8p_sudq_ft_pu (I/O), iohs8p_sudq_ft (I/O), io8prog_1v8_i2c_pd (I/O), io8prog_1v8_i2c_pu (I/O), io8prog_1v8_i2c (I/O), io8prog_3v3_i2c_pd (I/O), io8prog_3v3_i2c_pu (I/O), io8prog_3v3_i2c (I/O), io8ls_1v8_pd (I/O), io8ls_1v8_pu (I/O), io8ls_1v8 (I/O), io8ls_3v3_pd (I/O), io8ls_3v3_pu (I/O), io8ls_3v3 (I/O), io8fs_1v8_pd (I/O), io8fs_1v8_pu (I/O), io8fs_1v8 (I/O), io8fs_3v3_pd (I/O), io8fs_3v3_pu (I/O), io8fs_3v3 (I/O), io8ms_1v8_pd (I/O), io8ms_1v8_pu (I/O), io8ms_1v8 (I/O), io8ms_3v3_pd (I/O), io8ms_3v3_pu (I/O)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
