|   IBIS file stm32l451_452_462_ufbga100.ibs
[IBIS ver]   4.2
[File name]  stm32l451_452_462_ufbga100.ibs
[File Rev]   2.0
[Date]   08-10-2018
[Source]   Data Created at STMicroelectronics
[Disclaimer] This information is for modeling purpose only and is
   not guaranteed.
   The information is subject to change without notice.
[Copyright]  Copyright 2018 STMicroelectronics Inc.
|   Component stm32l451_452_462_ufbga100
[Component] stm32l451_452_462_ufbga100
[Manufacturer] STMicroelectronics
[Package]
| variable   typ   min   max
R_pkg   0.0   0.0   0.0
L_pkg   0.0H   0.0H   0.0H
C_pkg   0.0F   0.0F   0.0F
[Pin]  signal_name   model_name   R_pin   L_pin   C_pin
A1 PE3 io8prog2m25m50m120m_sudq_ft
A10 PA14 io8prog2m25m50m120m_sudq_ft
A11 PA13 io8prog2m25m50m120m_sudq_ft
A12 PA12 io8usb_id_otg20_lcd4_ft_ms
A2 PE1 io8prog2m25m50m120m_sudq_ft
A3 PB8 io8prog2m25m50m120m_sudq_i2c_ft
A4 PH3-BOOT0 io8prog2m25m50m120m_sudq_ft
A5 PD7 io8prog2m25m50m120m_sudq_ft
A6 PD5 io8prog2m25m50m120m_sudq_ft
A7 PB4 io8prog2m25m50m120m_sudq_i2c_ft
A8 PB3 io8prog2m25m50m120m_sudq_ft
A9 PA15 io8prog2m25m50m120m_sudq_ft
B1 PE4 io8prog2m25m50m120m_sudq_ft
B10 PC12 io8prog2m25m50m120m_sudq_ft
B11 PC10 io8prog2m25m50m120m_sudq_ft
B12 PA11 io8usb_id_otg20_lcd4_ft_ms
B2 PE2 io8prog2m25m50m120m_sudq_ft
B3 PB9 io8prog2m25m50m120m_sudq_i2c_ft
B4 PB7 io8prog2m25m50m120m_sudq_i2c_ft
B5 PB6 io8prog2m25m50m120m_sudq_i2c_ft
B6 PD6 io8prog2m25m50m120m_sudq_ft
B7 PD4 io8prog2m25m50m120m_sudq_ft
B8 PD3 io8prog2m25m50m120m_sudq_ft
B9 PD1 io8prog2m25m50m120m_sudq_ft
C1 PC13 io8prog2m25m50m120m_sudq_ft
C10 PC11 io8prog2m25m50m120m_sudq_ft
C11 VDD/VDDUSB POWER
C12 PA10 io8prog2m25m50m120m_sudq_i2c_ft
C2 PE5 io8prog2m25m50m120m_sudq_ft
C3 PE0 io8prog2m25m50m120m_sudq_ft
C4 VDD POWER
C5 PB5 io8prog2m25m50m120m_sudq_ft
C8 PD2 io8prog2m25m50m120m_sudq_ft
C9 PD0 io8prog2m25m50m120m_sudq_ft
D1 PC14-OSC32_IN io8prog2m25m50m120m_sudq_ft
D10 PA9 io8prog2m25m50m120m_sudq_i2c_ft
D11 PA8 io8prog2m25m50m120m_sudq_ft
D12 PC9 io8prog2m25m50m120m_sudq_ft
D2 PE6 io8prog2m25m50m120m_sudq_ft
D3 VSS GND
E1 PC15-OSC32_OUT io8prog2m25m50m120m_sudq_ft
E10 PC8 io8prog2m25m50m120m_sudq_ft
E11 PC7 io8prog2m25m50m120m_sudq_ft
E12 PC6 io8prog2m25m50m120m_sudq_ft
E2 VBAT POWER
E3 VSS GND
F1 PH0-OSC_IN io8prog2m25m50m120m_sudq_ft
F11 VSS GND
F12 VSS GND
F2 VSS GND
G1 PH1-OSC_OUT io8prog2m25m50m120m_sudq_ft
G11 VDD POWER
G12 VDD POWER
G2 VDD POWER
H1 PC0 io8prog2m25m50m120m_sudq_i2c_ft
H10 PD15 io8prog2m25m50m120m_sudq_ft
H11 PD14 io8prog2m25m50m120m_sudq_ft
H12 PD13 io8prog2m25m50m120m_sudq_i2c_ft
H2 NRST ioreset_ft_v33
H3 VDD POWER
J1 VSSA GND
J10 PD12 io8prog2m25m50m120m_sudq_i2c_ft
J11 PD11 io8prog2m25m50m120m_sudq_ft
J12 PD10 io8prog2m25m50m120m_sudq_ft
J2 PC1 io8prog2m25m50m120m_sudq_i2c_ft
J3 PC2 io8prog2m25m50m120m_sudq_ft
K1 VREF- GND
K10 PB15 io8prog2m25m50m120m_sudq_ft
K11 PB14 io8prog2m25m50m120m_sudq_i2c_ft
K12 PB13 io8prog2m25m50m120m_sudq_i2c_ft
K2 PC3 io8prog2m25m50m120m_sudq_ft
K3 PA2 io8prog2m25m50m120m_sudq_ft
K4 PA5 io8prog2m25m50m120m_sudq_ft
K5 PC4 io8prog2m25m50m120m_sudq_ft
K8 PD9 io8prog2m25m50m120m_sudq_ft
K9 PD8 io8prog2m25m50m120m_sudq_ft
L1 VREF+ POWER
L10 PB10 io8prog2m25m50m120m_sudq_i2c_ft
L11 PB11 io8prog2m25m50m120m_sudq_i2c_ft
L12 PB12 io8prog2m25m50m120m_sudq_ft
L2 PA0 io8prog2m25m50m120m_sudq_ft
L3 PA3 io8prog2m25m50m120m_sudq_ft
L4 PA6 io8prog2m25m50m120m_sudq_ft
L5 PC5 io8prog2m25m50m120m_sudq_ft
L6 PB2 io8prog2m25m50m120m_sudq_ft
L7 PE8 io8prog2m25m50m120m_sudq_ft
L8 PE10 io8prog2m25m50m120m_sudq_ft
L9 PE12 io8prog2m25m50m120m_sudq_ft
M1 VDDA POWER
M10 PE13 io8prog2m25m50m120m_sudq_ft
M11 PE14 io8prog2m25m50m120m_sudq_ft
M12 PE15 io8prog2m25m50m120m_sudq_ft
M2 PA1 io8prog2m25m50m120m_sudq_ft
M3 PA4 io8prog2m25m50m120m_sudq_ft
M4 PA7 io8prog2m25m50m120m_sudq_i2c_ft
M5 PB0 io8prog2m25m50m120m_sudq_ft
M6 PB1 io8prog2m25m50m120m_sudq_ft
M7 PE7 io8prog2m25m50m120m_sudq_ft
M8 PE9 io8prog2m25m50m120m_sudq_ft
M9 PE11 io8prog2m25m50m120m_sudq_ft
[Model Selector] io8prog2m25m50m120m_sudq_ft
iols8p_sudq_ft_pd_lv  "IO low speed, PD=40kOhm - 1P8V"
iols8p_sudq_ft_pu_lv  "IO low speed, PU=40kOhm - 1P8V"
iols8p_sudq_ft_lv  "IO low speed - 1P8V"
iols8p_sudq_ft_pd  "IO low speed, PD=40kOhm - 3P3V"
iols8p_sudq_ft_pu  "IO low speed, PU=40kOhm - 3P3V"
iols8p_sudq_ft  "IO low speed - 3P3V"
iofs8p_sudq_ft_pd_lv  "IO full speed, PD=40kOhm - 1P8V"
iofs8p_sudq_ft_pu_lv  "IO full speed, PU=40kOhm - 1P8V"
iofs8p_sudq_ft_lv  "IO full speed - 1P8V"
iofs8p_sudq_ft_pd  "IO full speed, PD=40kOhm - 3P3V"
iofs8p_sudq_ft_pu  "IO full speed, PU=40kOhm - 3P3V"
iofs8p_sudq_ft  "IO full speed - 3P3V"
ioms8p_sudq_ft_pd_lv  "IO medium speed, PD=40kOhm - 1P8V"
ioms8p_sudq_ft_pu_lv  "IO medium speed, PU=40kOhm - 1P8V"
ioms8p_sudq_ft_lv  "IO medium speed - 1P8V"
ioms8p_sudq_ft_pd  "IO medium speed, PD=40kOhm - 3P3V"
ioms8p_sudq_ft_pu  "IO medium speed, PU=40kOhm - 3P3V"
ioms8p_sudq_ft  "IO medium speed - 3P3V"
iohs8p_sudq_ft_pd_lv  "IO high speed, PD=40kOhm - 1P8V"
iohs8p_sudq_ft_pu_lv  "IO high speed, PU=40kOhm - 1P8V"
iohs8p_sudq_ft_lv  "IO high speed - 1P8V"
iohs8p_sudq_ft_pd  "IO high speed, PD=40kOhm - 3P3V"
iohs8p_sudq_ft_pu  "IO high speed, PU=40kOhm - 3P3V"
iohs8p_sudq_ft  "IO high speed - 3P3V"
[Model Selector] io8usb_id_otg20_lcd4_ft_ms
io8usbid_1v8_id_pu  "ID 1V8 range with pull up"
io8usbid_3v3_id_pu  "ID 3V3 range with pull up"
io8usbid_1v8_id  "ID 1V8 range"
io8usbid_3v3_id  "ID 3V3 range"
io8lsusbid_1v8_pd  "GPIO 1.8V range with pd io low speed"
io8lsusbid_1v8_pu  "GPIO 1.8V range with pu io low speed"
io8lsusbid_1v8  "GPIO 1.8V range io low speed"
io8lsusbid_3v3_pd  "GPIO 3.3V range with pd io low speed"
io8lsusbid_3v3_pu  "GPIO 3.3V range with pu io low speed"
io8lsusbid_3v3  "GPIO 3.3V range io low speed"
io8fsusbid_1v8_pd  "GPIO 1.8V range with pd io full speed"
io8fsusbid_1v8_pu  "GPIO 1.8V range with pu io full speed"
io8fsusbid_1v8  "GPIO 1.8V range io full speed"
io8fsusbid_3v3_pd  "GPIO 3.3V range with pd io full speed"
io8fsusbid_3v3_pu  "GPIO 3.3V range with pu io full speed"
io8fsusbid_3v3  "GPIO 3.3V range io full speed"
io8msusbid_1v8_pd  "GPIO 1.8V range with pd io medium speed"
io8msusbid_1v8_pu  "GPIO 1.8V range with pu io medium speed"
io8msusbid_1v8  "GPIO 1.8V range io medium speed"
io8msusbid_3v3_pd  "GPIO 3.3V range with pd io medium speed"
io8msusbid_3v3_pu  "GPIO 3.3V range with pu io medium speed"
io8msusbid_3v3  "GPIO 3.3V range io medium speed"
io8hsusbid_1v8_pd  "GPIO 1.8V range with pd io high speed"
io8hsusbid_1v8_pu  "GPIO 1.8V range with pu io high speed"
io8hsusbid_1v8  "GPIO 1.8V range io high speed"
io8hsusbid_3v3_pd  "GPIO 3.3V range with pd io high speed"
io8hsusbid_3v3_pu  "GPIO 3.3V range with pu io high speed"
io8hsusbid_3v3  "GPIO 3.3V range io high speed"
[Model Selector] io8prog2m25m50m120m_sudq_i2c_ft
io8prog_1v8_i2c_pd  "5V Tol GPIO 1.8V range i2c functionality with pull down"
io8prog_1v8_i2c_pu  "5V Tol GPIO 1.8V range i2c functionality with pull up"
io8prog_1v8_i2c  "5V Tol GPIO 1.8V range i2c functionality"
io8prog_3v3_i2c_pd  "5V Tol GPIO 3.3V range i2c functionality with pull down"
io8prog_3v3_i2c_pu  "5V Tol GPIO 3.3V range i2c functionality with pull up"
io8prog_3v3_i2c  "5V Tol GPIO 3.3V range i2c functionality"
io8ls_1v8_pd  "5V Tol GPIO 1.8V range with pd io low speed"
io8ls_1v8_pu  "5V Tol GPIO 1.8V range with pu io low speed"
io8ls_1v8  "5V Tol GPIO 1.8V range io low speed"
io8ls_3v3_pd  "5V Tol GPIO 3.3V range with pd io low speed"
io8ls_3v3_pu  "5V Tol GPIO 3.3V range with pu io low speed"
io8ls_3v3  "5V Tol GPIO 3.3V range io low speed"
io8fs_1v8_pd  "5V Tol GPIO 1.8V range with pd io full speed"
io8fs_1v8_pu  "5V Tol GPIO 1.8V range with pu io full speed"
io8fs_1v8  "5V Tol GPIO 1.8V range io full speed"
io8fs_3v3_pd  "5V Tol GPIO 3.3V range with pd io full speed"
io8fs_3v3_pu  "5V Tol GPIO 3.3V range with pu io full speed"
io8fs_3v3  "5V Tol GPIO 3.3V range io full speed"
io8ms_1v8_pd  "5V Tol GPIO 1.8V range with pd io medium speed"
io8ms_1v8_pu  "5V Tol GPIO 1.8V range with pu io medium speed"
io8ms_1v8  "5V Tol GPIO 1.8V range io medium speed"
io8ms_3v3_pd  "5V Tol GPIO 3.3V range with pd io medium speed"
io8ms_3v3_pu  "5V Tol GPIO 3.3V range with pu io medium speed"
io8ms_3v3  "5V Tol GPIO 3.3V range io medium speed"
io8hs_1v8_pd  "5V Tol GPIO 1.8V range with pd io high speed"
io8hs_1v8_pu  "5V Tol GPIO 1.8V range with pu io high speed"
io8hs_1v8  "5V Tol GPIO 1.8V range io high speed"
io8hs_3v3_pd  "5V Tol GPIO 3.3V range with pd io high speed"
io8hs_3v3_pu  "5V Tol GPIO 3.3V range with pu io high speed"
io8hs_3v3  "5V Tol GPIO 3.3V range io high speed"
[Model Selector] ioreset_ft_v33
ioreset_1v2_pu  "RESET 1.2V range with PU"
ioreset_1v2  "RESET 1.2V range"
ioreset_1v8_pu  "RESET 1.8V range with PU"
ioreset_1v8  "RESET 1.8V range"
ioreset_3v3_pu  "RESET 3.3V range with PU"
ioreset_3v3  "RESET 3.3V range"
| Models and submodels in the file (88): iols8p_sudq_ft_pd_lv (I/O), iols8p_sudq_ft_pu_lv (I/O), iols8p_sudq_ft_lv (I/O), iols8p_sudq_ft_pd (I/O), iols8p_sudq_ft_pu (I/O), iols8p_sudq_ft (I/O), iofs8p_sudq_ft_pd_lv (I/O), iofs8p_sudq_ft_pu_lv (I/O), iofs8p_sudq_ft_lv (I/O), iofs8p_sudq_ft_pd (I/O), iofs8p_sudq_ft_pu (I/O), iofs8p_sudq_ft (I/O), ioms8p_sudq_ft_pd_lv (I/O), ioms8p_sudq_ft_pu_lv (I/O), ioms8p_sudq_ft_lv (I/O), ioms8p_sudq_ft_pd (I/O), ioms8p_sudq_ft_pu (I/O), ioms8p_sudq_ft (I/O), iohs8p_sudq_ft_pd_lv (I/O), iohs8p_sudq_ft_pu_lv (I/O), iohs8p_sudq_ft_lv (I/O), iohs8p_sudq_ft_pd (I/O), iohs8p_sudq_ft_pu (I/O), iohs8p_sudq_ft (I/O), io8usbid_1v8_id_pu (Input), io8usbid_3v3_id_pu (Input), io8usbid_1v8_id (Input), io8usbid_3v3_id (Input), io8lsusbid_1v8_pd (I/O), io8lsusbid_1v8_pu (I/O), io8lsusbid_1v8 (I/O), io8lsusbid_3v3_pd (I/O), io8lsusbid_3v3_pu (I/O), io8lsusbid_3v3 (I/O), io8fsusbid_1v8_pd (I/O), io8fsusbid_1v8_pu (I/O), io8fsusbid_1v8 (I/O), io8fsusbid_3v3_pd (I/O), io8fsusbid_3v3_pu (I/O), io8fsusbid_3v3 (I/O), io8msusbid_1v8_pd (I/O), io8msusbid_1v8_pu (I/O), io8msusbid_1v8 (I/O), io8msusbid_3v3_pd (I/O), io8msusbid_3v3_pu (I/O), io8msusbid_3v3 (I/O), io8hsusbid_1v8_pd (I/O), io8hsusbid_1v8_pu (I/O), io8hsusbid_1v8 (I/O), io8hsusbid_3v3_pd (I/O), io8hsusbid_3v3_pu (I/O), io8hsusbid_3v3 (I/O), io8prog_1v8_i2c_pd (I/O), io8prog_1v8_i2c_pu (I/O), io8prog_1v8_i2c (I/O), io8prog_3v3_i2c_pd (I/O), io8prog_3v3_i2c_pu (I/O), io8prog_3v3_i2c (I/O), io8ls_1v8_pd (I/O), io8ls_1v8_pu (I/O), io8ls_1v8 (I/O), io8ls_3v3_pd (I/O), io8ls_3v3_pu (I/O), io8ls_3v3 (I/O), io8fs_1v8_pd (I/O), io8fs_1v8_pu (I/O), io8fs_1v8 (I/O), io8fs_3v3_pd (I/O), io8fs_3v3_pu (I/O), io8fs_3v3 (I/O), io8ms_1v8_pd (I/O), io8ms_1v8_pu (I/O), io8ms_1v8 (I/O), io8ms_3v3_pd (I/O), io8ms_3v3_pu (I/O), io8ms_3v3 (I/O), io8hs_1v8_pd (I/O), io8hs_1v8_pu (I/O), io8hs_1v8 (I/O), io8hs_3v3_pd (I/O)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
