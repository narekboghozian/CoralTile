|   IBIS file stm32l431_433_443_wlcsp64.ibs
[IBIS ver]   4.2
[File name]   stm32l431_433_443_wlcsp64.ibs
[File Rev]   4.0
[Date]   08-10-2018
[Source]   Data Created at STMicroelectronics
[Notes]   File originated from ELDO simulations.
[Disclaimer]  This information is for modeling purpose only and is
   not guaranteed.
   The information is subject to change without notice.
[Copyright]   Copyright 2018 STMicroelectronics Inc.
|   Component stm32l431_433_443_wlcsp64
[Component] stm32l431_433_443_wlcsp64|
[Manufacturer] STMicroelectronics
[Package]
| variable   typ   min   max
R_pkg   0.0   0.0   0.0
L_pkg   0.0H   0.0H   0.0H
C_pkg   0.0F   0.0F   0.0F
[Pin]  signal_name   model_name   R_pin   L_pin   C_pin
A1 VDD/VDDUSB POWER
A2 PA15 io8prog2m25m50m120m_sudq_ft
A3 PC12 io8prog2m25m50m120m_sudq_ft
A4 PD2 io8prog2m25m50m120m_sudq_ft
A5 PB3 io8prog2m25m50m120m_sudq_ft
A6 PB7 io8prog2m25m50m120m_sudq_i2c_ft
A7 VSS GND
A8 VDD POWER
B1 VSS GND
B2 PA14 io8prog2m25m50m120m_sudq_ft
B3 PC11 io8prog2m25m50m120m_sudq_ft
B4 PB4 io8prog2m25m50m120m_sudq_i2c_ft
B5 PB6 io8prog2m25m50m120m_sudq_i2c_ft
B6 PB9 io8prog2m25m50m120m_sudq_i2c_ft
B7 VBAT POWER
B8 PC13 io8prog2m25m50m120m_sudq_ft
C1 PA12 io8usblsfs_otg2
C2 PA13 io8prog2m25m50m120m_sudq_ft
C3 PC10 io8prog2m25m50m120m_sudq_ft
C4 PB5 io8prog2m25m50m120m_sudq_ft
C5 PH3/BOOT0 io8prog2m25m50m120m_sudq_ft
C6 PB8 io8prog2m25m50m120m_sudq_i2c_ft
C7 PC15-OSC32_OUT io8prog2m25m50m120m_sudq_ft
C8 PC14-OSC32_IN io8prog2m25m50m120m_sudq_ft
D1 PA9 io8prog2m25m50m120m_sudq_i2c_ft
D2 PA10 io8prog2m25m50m120m_sudq_i2c_ft
D3 PA11 io8usblsfs_otg2
D4 PC4 io8prog2m25m50m120m_sudq_ft
D5 PC0 io8prog2m25m50m120m_sudq_i2c_ft
D6 NRST ioreset_ft_v33
D7 PH1-OSC_OUT io8prog2m25m50m120m_sudq_ft
D8 PH0-OSC_IN io8prog2m25m50m120m_sudq_ft
E1 PC7 io8prog2m25m50m120m_sudq_ft
E2 PC9 io8prog2m25m50m120m_sudq_ft
E3 PA8 io8w_swp_lcd4_ft
E4 PC5 io8prog2m25m50m120m_sudq_ft
E5 PA4 io8prog2m25m50m120m_sudq_ft
E6 PC3 io8prog2m25m50m120m_sudq_ft
E7 PC2 io8prog2m25m50m120m_sudq_ft
E8 PC1 io8prog2m25m50m120m_sudq_i2c_ft
F1 PC6 io8prog2m25m50m120m_sudq_ft
F2 PB15 io8prog2m25m50m120m_sudq_ft
F3 PC8 io8prog2m25m50m120m_sudq_ft
F4 PB0 io8prog2m25m50m120m_sudq_ft
F5 PA5 io8prog2m25m50m120m_sudq_ft
F6 PA2 io8prog2m25m50m120m_sudq_ft
F7 PA0 io8prog2m25m50m120m_sudq_ft
F8 VSSA/VREF- GND
G1 PB14 io8prog2m25m50m120m_sudq_i2c_ft
G2 PB13 io8prog2m25m50m120m_sudq_i2c_ft
G3 PB12 io8w_swp_lcd4_ft
G4 PB2 io8prog2m25m50m120m_sudq_ft
G5 PA6 io8prog2m25m50m120m_sudq_ft
G6 PA3 io8prog2m25m50m120m_sudq_ft
G7 PA1 io8prog2m25m50m120m_sudq_ft
G8 VDDA/VREF+ POWER
H1 VDD POWER
H2 VSS GND
H3 PB11 io8prog2m25m50m120m_sudq_i2c_ft
H4 PB10 io8prog2m25m50m120m_sudq_i2c_ft
H5 PB1 io8prog2m25m50m120m_sudq_ft
H6 PA7 io8prog2m25m50m120m_sudq_i2c_ft
H7 VDD POWER
H8 VSS GND
[Model Selector] io8prog2m25m50m120m_sudq_ft
iols8p_sudq_ft_pd_lv  "IO low speed, PD=40kOhm - 1P8V"
iols8p_sudq_ft_pu_lv  "IO low speed, PU=40kOhm - 1P8V"
iols8p_sudq_ft_lv  "IO low speed - 1P8V"
iols8p_sudq_ft_pd  "IO low speed, PD=40kOhm - 3P3V"
iols8p_sudq_ft_pu  "IO low speed, PU=40kOhm - 3P3V"
iols8p_sudq_ft  "IO low speed - 3P3V"
iofs8p_sudq_ft_pd_lv  "IO full speed, PD=40kOhm - 1P8V"
iofs8p_sudq_ft_pu_lv  "IO full speed, PU=40kOhm - 1P8V"
iofs8p_sudq_ft_lv  "IO full speed - 1P8V"
iofs8p_sudq_ft_pd  "IO full speed, PD=40kOhm - 3P3V"
iofs8p_sudq_ft_pu  "IO full speed, PU=40kOhm - 3P3V"
iofs8p_sudq_ft  "IO full speed - 3P3V"
ioms8p_sudq_ft_pd_lv  "IO medium speed, PD=40kOhm - 1P8V"
ioms8p_sudq_ft_pu_lv  "IO medium speed, PU=40kOhm - 1P8V"
ioms8p_sudq_ft_lv  "IO medium speed - 1P8V"
ioms8p_sudq_ft_pd  "IO medium speed, PD=40kOhm - 3P3V"
ioms8p_sudq_ft_pu  "IO medium speed, PU=40kOhm - 3P3V"
ioms8p_sudq_ft  "IO medium speed - 3P3V"
iohs8p_sudq_ft_pd_lv  "IO high speed, PD=40kOhm - 1P8V"
iohs8p_sudq_ft_pu_lv  "IO high speed, PU=40kOhm - 1P8V"
iohs8p_sudq_ft_lv  "IO high speed - 1P8V"
iohs8p_sudq_ft_pd  "IO high speed, PD=40kOhm - 3P3V"
iohs8p_sudq_ft_pu  "IO high speed, PU=40kOhm - 3P3V"
iohs8p_sudq_ft  "IO high speed - 3P3V"
[Model Selector] io8prog2m25m50m120m_sudq_i2c_ft
io8prog_1v8_i2c_pd  "5V Tol GPIO 1.8V range i2c functionality with pull down"
io8prog_1v8_i2c_pu  "5V Tol GPIO 1.8V range i2c functionality with pull up"
io8prog_1v8_i2c  "5V Tol GPIO 1.8V range i2c functionality"
io8prog_3v3_i2c_pd  "5V Tol GPIO 3.3V range i2c functionality with pull down"
io8prog_3v3_i2c_pu  "5V Tol GPIO 3.3V range i2c functionality with pull up"
io8prog_3v3_i2c  "5V Tol GPIO 3.3V range i2c functionality"
io8ls_1v8_pd  "5V Tol GPIO 1.8V range with pd io low speed"
io8ls_1v8_pu  "5V Tol GPIO 1.8V range with pu io low speed"
io8ls_1v8  "5V Tol GPIO 1.8V range io low speed"
io8ls_3v3_pd  "5V Tol GPIO 3.3V range with pd io low speed"
io8ls_3v3_pu  "5V Tol GPIO 3.3V range with pu io low speed"
io8ls_3v3  "5V Tol GPIO 3.3V range io low speed"
io8fs_1v8_pd  "5V Tol GPIO 1.8V range with pd io full speed"
io8fs_1v8_pu  "5V Tol GPIO 1.8V range with pu io full speed"
io8fs_1v8  "5V Tol GPIO 1.8V range io full speed"
io8fs_3v3_pd  "5V Tol GPIO 3.3V range with pd io full speed"
io8fs_3v3_pu  "5V Tol GPIO 3.3V range with pu io full speed"
io8fs_3v3  "5V Tol GPIO 3.3V range io full speed"
io8ms_1v8_pd  "5V Tol GPIO 1.8V range with pd io medium speed"
io8ms_1v8_pu  "5V Tol GPIO 1.8V range with pu io medium speed"
io8ms_1v8  "5V Tol GPIO 1.8V range io medium speed"
io8ms_3v3_pd  "5V Tol GPIO 3.3V range with pd io medium speed"
io8ms_3v3_pu  "5V Tol GPIO 3.3V range with pu io medium speed"
io8ms_3v3  "5V Tol GPIO 3.3V range io medium speed"
io8hs_1v8_pd  "5V Tol GPIO 1.8V range with pd io high speed"
io8hs_1v8_pu  "5V Tol GPIO 1.8V range with pu io high speed"
io8hs_1v8  "5V Tol GPIO 1.8V range io high speed"
io8hs_3v3_pd  "5V Tol GPIO 3.3V range with pd io high speed"
io8hs_3v3_pu  "5V Tol GPIO 3.3V range with pu io high speed"
io8hs_3v3  "5V Tol GPIO 3.3V range io high speed"
[Model Selector] io8usblsfs_otg2
usb_ls_pd  "USB Low Speed mode - Pull Down"
usb_ls_pu2  "USB Low Speed mode - Pull up 2"
usb_ls_pu  "USB Low Speed mode - Pull up"
usb_fs  "USB Low Speed mode"
usb_fs_pd  "USB Full Speed mode - Pull Down"
usb_fs_pu2  "USB Full Speed mode - Pull up 2"
usb_fs_pu  "USB Full Speed mode - Pull up"
[Model Selector] ioreset_ft_v33
ioreset_1v2_pu  "RESET 1.2V range with PU"
ioreset_1v2  "RESET 1.2V range"
ioreset_1v8_pu  "RESET 1.8V range with PU"
ioreset_1v8  "RESET 1.8V range"
ioreset_3v3_pu  "RESET 3.3V range with PU"
ioreset_3v3  "RESET 3.3V range"
[Model Selector] io8w_swp_lcd4_ft
io8w_swp_classc  "Class C swp functionality"
io8w_swp_classb  "Class B swp functionality"
io8lsw_1v8_pd  "GPIO 1.8V range with pd io low speed"
io8lsw_1v8_pu  "GPIO 1.8V range with pu io low speed"
io8lsw_1v8  "GPIO 1.8V range io low speed"
io8lsw_3v3_pd  "GPIO 3.3V range with pd io low speed"
io8lsw_3v3_pu  "GPIO 3.3V range with pu io low speed"
io8lsw_3v3  "GPIO 3.3V range io low speed"
io8fsw_1v8_pd  "GPIO 1.8V range with pd io full speed"
io8fsw_1v8_pu  "GPIO 1.8V range with pu io full speed"
io8fsw_1v8  "GPIO 1.8V range io full speed"
io8fsw_3v3_pd  "GPIO 3.3V range with pd io full speed"
io8fsw_3v3_pu  "GPIO 3.3V range with pu io full speed"
io8fsw_3v3  "GPIO 3.3V range io full speed"
io8msw_1v8_pd  "GPIO 1.8V range with pd io medium speed"
io8msw_1v8_pu  "GPIO 1.8V range with pu io medium speed"
io8msw_1v8  "GPIO 1.8V range io medium speed"
io8msw_3v3_pd  "GPIO 3.3V range with pd io medium speed"
io8msw_3v3_pu  "GPIO 3.3V range with pu io medium speed"
io8msw_3v3  "GPIO 3.3V range io medium speed"
io8hsw_1v8_pd  "GPIO 1.8V range with pd io high speed"
io8hsw_1v8_pu  "GPIO 1.8V range with pu io high speed"
io8hsw_1v8  "GPIO 1.8V range io high speed"
io8hsw_3v3_pd  "GPIO 3.3V range with pd io high speed"
io8hsw_3v3_pu  "GPIO 3.3V range with pu io high speed"
io8hsw_3v3  "GPIO 3.3V range io high speed"
| Models and submodels in the file (93): iols8p_sudq_ft_pd_lv (I/O), iols8p_sudq_ft_pu_lv (I/O), iols8p_sudq_ft_lv (I/O), iols8p_sudq_ft_pd (I/O), iols8p_sudq_ft_pu (I/O), iols8p_sudq_ft (I/O), iofs8p_sudq_ft_pd_lv (I/O), iofs8p_sudq_ft_pu_lv (I/O), iofs8p_sudq_ft_lv (I/O), iofs8p_sudq_ft_pd (I/O), iofs8p_sudq_ft_pu (I/O), iofs8p_sudq_ft (I/O), ioms8p_sudq_ft_pd_lv (I/O), ioms8p_sudq_ft_pu_lv (I/O), ioms8p_sudq_ft_lv (I/O), ioms8p_sudq_ft_pd (I/O), ioms8p_sudq_ft_pu (I/O), ioms8p_sudq_ft (I/O), iohs8p_sudq_ft_pd_lv (I/O), iohs8p_sudq_ft_pu_lv (I/O), iohs8p_sudq_ft_lv (I/O), iohs8p_sudq_ft_pd (I/O), iohs8p_sudq_ft_pu (I/O), iohs8p_sudq_ft (I/O), io8prog_1v8_i2c_pd (I/O), io8prog_1v8_i2c_pu (I/O), io8prog_1v8_i2c (I/O), io8prog_3v3_i2c_pd (I/O), io8prog_3v3_i2c_pu (I/O), io8prog_3v3_i2c (I/O), io8ls_1v8_pd (I/O), io8ls_1v8_pu (I/O), io8ls_1v8 (I/O), io8ls_3v3_pd (I/O), io8ls_3v3_pu (I/O), io8ls_3v3 (I/O), io8fs_1v8_pd (I/O), io8fs_1v8_pu (I/O), io8fs_1v8 (I/O), io8fs_3v3_pd (I/O), io8fs_3v3_pu (I/O), io8fs_3v3 (I/O), io8ms_1v8_pd (I/O), io8ms_1v8_pu (I/O), io8ms_1v8 (I/O), io8ms_3v3_pd (I/O), io8ms_3v3_pu (I/O), io8ms_3v3 (I/O), io8hs_1v8_pd (I/O), io8hs_1v8_pu (I/O), io8hs_1v8 (I/O), io8hs_3v3_pd (I/O), io8hs_3v3_pu (I/O), io8hs_3v3 (I/O), usb_ls_pd (I/O), usb_ls_pu2 (I/O), usb_ls_pu (I/O), usb_fs (I/O), usb_fs_pd (I/O), usb_fs_pu2 (I/O), usb_fs_pu (I/O), ioreset_1v2_pu (I/O_open_drain), ioreset_1v2 (I/O_open_drain), ioreset_1v8_pu (I/O_open_drain), ioreset_1v8 (I/O_open_drain), ioreset_3v3_pu (I/O_open_drain), ioreset_3v3 (I/O_open_drain), io8w_swp_classc (I/O), io8w_swp_classb (I/O), io8lsw_1v8_pd (I/O), io8lsw_1v8_pu (I/O), io8lsw_1v8 (I/O), io8lsw_3v3_pd (I/O), io8lsw_3v3_pu (I/O), io8lsw_3v3 (I/O), io8fsw_1v8_pd (I/O), io8fsw_1v8_pu (I/O), io8fsw_1v8 (I/O), io8fsw_3v3_pd (I/O), io8fsw_3v3_pu (I/O)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
